** hier_three_level — depth-3 hierarchy (amp2 -> gain_block -> ota5t)
.subckt amp2 in out vdd gnd vbias vref
Xg1 in mid vdd gnd vbias vref gain_block
Xg2 mid out vdd gnd vbias vref gain_block
.ends

.subckt gain_block in out vdd gnd vbias vref
Xota in vref out vdd gnd vbias ota5t
R1 out gnd 50k
C1 out gnd 200f
.ends

.subckt ota5t inp inn out vdd gnd vbias
M1 d1 inp tail gnd nmos W=8u L=0.5u
M2 out inn tail gnd nmos W=8u L=0.5u
M3 d1 d1 vdd vdd pmos W=8u L=0.5u
M4 out d1 vdd vdd pmos W=8u L=0.5u
M5 tail vbias gnd gnd nmos W=8u L=0.5u
.ends

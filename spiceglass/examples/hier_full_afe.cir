** full_afe (hierarchical system)
.subckt full_afe_00024 rfin vref dout vdd gnd vbias vbn
Xlna rfin s1 vdd gnd vbias lna_common_source_lna
Xflt s1 s2 vdd gnd vbn gm_c_biquad_flt
Xcmp s2 vref s3 vdd gnd vbias comparator_cmp
Xbuf vdd gnd s3 dout inverter_chain_buf
.ends
.subckt lna_common_source_lna rfin out vdd gnd vbias
Lg rfin g 10p
Rb vbias g 1k
M1 out g s gnd nmos W=8u L=0.18u
Ls s gnd 10p
Ld vdd out 250f
Ct out gnd 500f
.ends
.subckt gm_c_biquad_flt in out vdd gnd vbn
** ===== gm1 =====
Ma1 x1 in ta gnd nmos W=40u L=0.35u
Ma2 dxa x1 ta gnd nmos W=40u L=0.35u
Mat ta vbn gnd gnd nmos W=40u L=0.35u
Ma3 x1 dxa vdd vdd pmos W=40u L=0.35u
Ma4 dxa dxa vdd vdd pmos W=40u L=0.35u
** ===== gm2 =====
Mb1 out x1 tb gnd nmos W=40u L=0.35u
Mb2 dxb out tb gnd nmos W=40u L=0.35u
Mbt tb vbn gnd gnd nmos W=40u L=0.35u
Mb3 out dxb vdd vdd pmos W=40u L=0.35u
Mb4 dxb dxb vdd vdd pmos W=40u L=0.35u
C1 x1 gnd 10p
C2 out gnd 500f
.ends
.subckt comparator_cmp inp inn out vdd gnd vbias
** ===== Input Pair =====
M1 d1 inp tail gnd nmos W=20u L=0.5u
M2 d2 inn tail gnd nmos W=20u L=0.5u
M5 tail vbias gnd gnd nmos W=20u L=0.5u
** ===== Mirror Load =====
M3 d1 d1 vdd vdd pmos W=20u L=0.5u
M4 d2 d1 vdd vdd pmos W=20u L=0.5u
** ===== Output Inverter =====
M6 out d2 vdd vdd pmos W=8u L=0.5u
M7 out d2 gnd gnd nmos W=10u L=0.5u
.ends
.subckt inverter_chain_buf vdd gnd in out
** ===== Inverter 1 =====
Mp0 n0 in vdd vdd pmos W=4u L=2u
Mn0 n0 in gnd gnd nmos W=2u L=2u
** ===== Inverter 2 =====
Mp1 n1 n0 vdd vdd pmos W=12u L=2u
Mn1 n1 n0 gnd gnd nmos W=6u L=2u
** ===== Inverter 3 =====
Mp2 out n1 vdd vdd pmos W=36u L=2u
Mn2 out n1 gnd gnd nmos W=18u L=2u
CL out gnd 500f
.ends

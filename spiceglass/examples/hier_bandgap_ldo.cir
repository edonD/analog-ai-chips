** bandgap_ldo (hierarchical system)
.subckt bandgap_ldo_00000 vdd gnd vout vbn
Xbg vdd gnd vref bandgap_core_bg
Xreg vref vdd vout gnd vbn ldo_reg
Cout vout gnd 10p
.ends
.subckt bandgap_core_bg vdd gnd vbg
** ===== PTAT BJT Branches =====
Q1 vc1 vc1 gnd npn
Q2 vc2 vc2 ne npn
R1 ne gnd 2k
** ===== Amp + Mirror =====
M1 vc1 vc1 vdd vdd pmos W=4u L=0.5u
M2 vc2 vc1 vdd vdd pmos W=2u L=0.18u
M3 vbg vc1 vdd vdd pmos W=8u L=2u
R2 vbg vbg2 50k
Q3 vbg2 vbg2 gnd npn
.ends
.subckt ldo_reg vref vdd vout gnd vbn
** ===== Error Amp (5T) =====
M1 d1 vref tail gnd nmos W=10u L=0.5u
M2 eo fb tail gnd nmos W=10u L=0.5u
M5 tail vbn gnd gnd nmos W=10u L=0.5u
M3 d1 d1 vdd vdd pmos W=10u L=0.5u
M4 eo d1 vdd vdd pmos W=10u L=0.5u
** ===== Pass Device =====
Mp vout eo vdd vdd pmos W=40u L=0.5u
** ===== Feedback Divider =====
Rf1 vout fb 50k
Rf2 fb gnd 5k
Cl vout gnd 250f
.ends

** rf_mixer_chain (hierarchical system)
.subckt rf_mixer_chain_00016 rfp rfn lop lon ifp ifn vdd gnd vbias vbc vbn
Xlna rfp rfn mp mn vdd gnd vbias vbc diff_lna_lna
Xmix lop lon mp mn ifp ifn vdd gnd vbn gilbert_cell_mix
.ends
.subckt diff_lna_lna rfp rfn outp outn vdd gnd vbias vbc
** ===== Input Match =====
Lgp rfp gp 5p
Lgn rfn gn 10p
Rbp vbias gp 100k
Rbn vbias gn 5k
** ===== Cascode Pair =====
M1 mp gp sp gnd nmos W=32u L=1u
M2 mn gn sn gnd nmos W=32u L=1u
Lsp sp gnd 5p
Lsn sn gnd 5p
M3 outp vbc mp gnd nmos W=32u L=1u
M4 outn vbc mn gnd nmos W=32u L=1u
Ldp vdd outp 500f
Ldn vdd outn 100f
.ends
.subckt gilbert_cell_mix lop lon rfp rfn outp outn vdd gnd vbn
M0 tail vbn gnd gnd nmos W=20u L=0.5u
** ===== RF Pair =====
M1 a rfp tail gnd nmos W=20u L=0.5u
M2 b rfn tail gnd nmos W=20u L=0.5u
** ===== LO Quad =====
M3 outp lop a gnd nmos W=20u L=0.5u
M4 outn lon a gnd nmos W=20u L=0.5u
M5 outp lon b gnd nmos W=20u L=0.5u
M6 outn lop b gnd nmos W=20u L=0.5u
R1 vdd outp 10k
R2 vdd outn 5k
.ends

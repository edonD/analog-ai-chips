** comparator (realistic template variant)
.subckt comparator_0001 inp inn out vdd gnd vbias
** ===== Input Pair =====
M1 d1 inp tail gnd nmos W=16u L=0.18u
M2 d2 inn tail gnd nmos W=16u L=0.18u
M5 tail vbias gnd gnd nmos W=16u L=0.18u
** ===== Mirror Load =====
M3 d1 d1 vdd vdd pmos W=16u L=0.18u
M4 d2 d1 vdd vdd pmos W=16u L=0.18u
** ===== Output Inverter =====
M6 out d2 vdd vdd pmos W=4u L=0.18u
M7 out d2 gnd gnd nmos W=10u L=0.18u
.ends comparator_0001

** lna_cascode (realistic template variant)
.subckt lna_cascode_0001 rfin out vdd gnd vbias vbc
** ===== Input Match =====
Lg rfin g 5p
Rb vbias g 5k
** ===== Cascode Gain =====
M1 mid g s gnd nmos W=4u L=1u
Ls s gnd 5p
M2 out vbc mid gnd nmos W=4u L=1u
** ===== Output Tank =====
Ld vdd out 1p
Ct out gnd 2p
.ends lna_cascode_0001

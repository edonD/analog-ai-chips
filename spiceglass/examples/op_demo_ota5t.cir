* OP demo — 5T OTA with generic models + bias (simulatable; for `glass op`
* and the editor's OP overlay). Swap a bias to see a stage fall out of sat.
.model nm nmos (level=1 vto=0.5 kp=120u lambda=0.02)
.model pm pmos (level=1 vto=-0.5 kp=40u lambda=0.04)
Vdd vdd 0 1.8
Vcm inp 0 0.9
Vfb inn 0 0.9
Vbias vbias 0 0.7
M1 d1 inp tail 0 nm W=10u L=0.5u
M2 out inn tail 0 nm W=10u L=0.5u
M3 d1 d1 vdd vdd pm W=10u L=0.5u
M4 out d1 vdd vdd pm W=10u L=0.5u
M5 tail vbias 0 0 nm W=20u L=0.5u

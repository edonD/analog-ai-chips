.subckt cmp_inverter_chain in out vdd gnd
** CMOS inverter chain (tapered buffer, fanout ~3)
** ===== Inverter 1 =====
Mp1 n1 in vdd vdd pmos W=2u L=0.18u
Mn1 n1 in gnd gnd nmos W=1u L=0.18u
** ===== Inverter 2 =====
Mp2 n2 n1 vdd vdd pmos W=6u L=0.18u
Mn2 n2 n1 gnd gnd nmos W=3u L=0.18u
** ===== Inverter 3 =====
Mp3 n3 n2 vdd vdd pmos W=18u L=0.18u
Mn3 n3 n2 gnd gnd nmos W=9u L=0.18u
** ===== Inverter 4 (output) =====
Mp4 out n3 vdd vdd pmos W=54u L=0.18u
Mn4 out n3 gnd gnd nmos W=27u L=0.18u
Cload out gnd 50f
.ends cmp_inverter_chain

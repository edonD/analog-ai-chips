.subckt cmp_levelshifter in out vdd svdd gnd
** Low-to-high cross-coupled level shifter (vdd domain -> svdd domain)
** ===== Input Inverter (vdd domain) =====
Minp inb in vdd vdd pmos W=4u L=0.18u
Minn inb in gnd gnd nmos W=2u L=0.18u
** ===== Pull-Down Drivers =====
Mnd1 d1 in gnd gnd nmos W=6u L=0.18u
Mnd2 d2 inb gnd gnd nmos W=6u L=0.18u
** ===== Cross-Coupled Pull-Up (svdd domain) =====
Mpu1 d1 d2 svdd svdd pmos W=8u L=0.18u
Mpu2 d2 d1 svdd svdd pmos W=8u L=0.18u
** ===== Output Inverter (svdd domain) =====
Mop out d1 svdd svdd pmos W=10u L=0.18u
Mon out d1 gnd gnd nmos W=5u L=0.18u
.ends cmp_levelshifter

** Fully-Differential OTA with Common-Mode Feedback
** NMOS input pair, PMOS cascode loads, switched-R CMFB sense network
.subckt ota_fulldiff_cmfb inp inn outp outn vdd gnd vbias vbcp vcmref

** ===== Tail =====
M1 tail vbias gnd gnd nmos W=80u L=1u

** ===== Differential Pair =====
M2 outn inp tail gnd nmos W=40u L=0.5u
M3 outp inn tail gnd nmos W=40u L=0.5u

** ===== PMOS Cascode Loads =====
M4 outn vbcp a1 vdd pmos W=60u L=0.6u
M5 outp vbcp a2 vdd pmos W=60u L=0.6u
M6 a1 vcmctrl vdd vdd pmos W=60u L=1u
M7 a2 vcmctrl vdd vdd pmos W=60u L=1u

** ===== CMFB Sense Network =====
Rcm1 outp vcm 50k
Rcm2 outn vcm 50k
Ccm1 outp vcm 0.2p
Ccm2 outn vcm 0.2p

** ===== CMFB Amplifier =====
M8  cmtail vbias gnd gnd nmos W=40u L=1u
M9  e1 vcm    cmtail gnd nmos W=20u L=0.5u
M10 vcmctrl vcmref cmtail gnd nmos W=20u L=0.5u
M11 e1 e1 vdd vdd pmos W=20u L=1u
M12 vcmctrl e1 vdd vdd pmos W=20u L=1u

.ends ota_fulldiff_cmfb

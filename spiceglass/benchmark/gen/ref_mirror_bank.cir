** Simple NMOS current mirror bank: 1 diode-connected reference + 4 ratioed outputs
.subckt ref_mirror_bank vdd gnd iref iout1 iout2 iout3 iout4

** ===== Reference Branch =====
* External pull on iref sets the reference current; M0 is diode-connected
M0 iref iref gnd gnd nmos W=4u L=1u

** ===== Mirror Bank =====
* All mirrors share the gate net 'iref' with the diode-connected device
M1 iout1 iref gnd gnd nmos W=4u L=1u
M2 iout2 iref gnd gnd nmos W=8u L=1u
M3 iout3 iref gnd gnd nmos W=16u L=1u
M4 iout4 iref gnd gnd nmos W=2u L=1u
* 2-series unit device for a 0.5x (half-current) tap
M5 iout4 iref gnd gnd nmos W=2u L=2u

.ends ref_mirror_bank

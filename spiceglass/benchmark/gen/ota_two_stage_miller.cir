** Two-Stage Miller-Compensated OTA
** Stage 1: PMOS input pair + NMOS mirror load
** Stage 2: NMOS common-source + PMOS active load, Miller cap Cc with Rz
.subckt ota_two_stage_miller inp inn out vdd gnd vbias

** ===== Tail =====
M0 tail vbias vdd vdd pmos W=80u L=1u

** ===== Differential Pair =====
M1 n1 inp tail vdd pmos W=40u L=0.5u
M2 n2 inn tail vdd pmos W=40u L=0.5u

** ===== Mirror Load =====
M3 n1 n1 gnd gnd nmos W=20u L=0.5u
M4 n2 n1 gnd gnd nmos W=20u L=0.5u

** ===== Second Stage =====
M5 out n2 gnd gnd nmos W=80u L=0.5u
M6 out vbias vdd vdd pmos W=160u L=1u

** ===== Miller Compensation =====
Rz n2 cz 2k
Cc cz out 2p

.ends ota_two_stage_miller

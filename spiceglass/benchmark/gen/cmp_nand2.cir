.subckt cmp_nand2 a b out vdd gnd
** 2-input CMOS NAND gate with output inverter (-> AND)
** ===== NAND Pull-Up (parallel PMOS) =====
Mpa nand a vdd vdd pmos W=4u L=0.18u
Mpb nand b vdd vdd pmos W=4u L=0.18u
** ===== NAND Pull-Down (series NMOS) =====
Mna nand a mid gnd nmos W=4u L=0.18u
Mnb mid b gnd gnd nmos W=4u L=0.18u
** ===== Output Inverter =====
Mop out nand vdd vdd pmos W=4u L=0.18u
Mon out nand gnd gnd nmos W=2u L=0.18u
.ends cmp_nand2

.subckt cmp_strongarm inp inn clk out outb vdd gnd
** StrongARM dynamic latch comparator
** ===== Tail Clock Switch =====
Mtail tail clk gnd gnd nmos W=24u L=0.18u
** ===== Input Pair =====
Min1 di1 inp tail gnd nmos W=16u L=0.18u
Min2 di2 inn tail gnd nmos W=16u L=0.18u
** ===== Cross-Coupled Latch (NMOS) =====
Mln1 outb di1 out gnd nmos W=8u L=0.18u
Mln2  out di2 outb gnd nmos W=8u L=0.18u
** ===== Cross-Coupled Latch (PMOS) =====
Mlp1 outb out vdd vdd pmos W=12u L=0.18u
Mlp2 out outb vdd vdd pmos W=12u L=0.18u
** ===== Reset / Precharge Switches =====
Mpr1 out clk vdd vdd pmos W=6u L=0.18u
Mpr2 outb clk vdd vdd pmos W=6u L=0.18u
Mpd1 di1 clk vdd vdd pmos W=4u L=0.18u
Mpd2 di2 clk vdd vdd pmos W=4u L=0.18u
.ends cmp_strongarm

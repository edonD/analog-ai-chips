.subckt cmp_continuous inp inn out vdd gnd
** Continuous-time comparator: diff pair + gain stage + output buffer
** ===== Tail Current Source =====
Mtail tail vbias gnd gnd nmos W=20u L=1u
Mbias vbias vbias gnd gnd nmos W=2u L=1u
Rbias vdd vbias 50k
** ===== Input Pair =====
Min1 d1 inp tail gnd nmos W=10u L=0.5u
Min2 d2 inn tail gnd nmos W=10u L=0.5u
** ===== Active Load (mirror) =====
Mld1 d1 d1 vdd vdd pmos W=15u L=0.5u
Mld2 d2 d1 vdd vdd pmos W=15u L=0.5u
** ===== Gain Stage =====
Mgn d2 d2 gnd gnd nmos W=8u L=0.5u
Mgp gso d2 vdd vdd pmos W=30u L=0.5u
Mgnd gso vbias gnd gnd nmos W=12u L=1u
Cc d2 gso 0.5p
** ===== Output Buffer =====
Mbp out gso vdd vdd pmos W=24u L=0.35u
Mbn out gso gnd gnd nmos W=8u L=0.35u
.ends cmp_continuous

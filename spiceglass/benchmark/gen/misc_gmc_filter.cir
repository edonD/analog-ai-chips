** First-order gm-C low-pass filter
** Single-stage differential-pair OTA driving an integrating capacitor
.subckt misc_gmc_filter vin vout vbias vdd gnd

** ===== Transconductor (OTA input pair) =====
M1 outp vin tail gnd nmos W=20u L=0.5u
M2 outn vout tail gnd nmos W=20u L=0.5u
M3 tail vbias gnd gnd nmos W=40u L=1u

** ===== Active load (current mirror) =====
M4 outp outp vdd vdd pmos W=40u L=0.5u
M5 outn outp vdd vdd pmos W=40u L=0.5u

** ===== Output buffer =====
M6 vout outn vdd vdd pmos W=30u L=0.5u
M7 vout vbias gnd gnd nmos W=15u L=1u

** ===== Integrating cap (gm-C pole) =====
C1 vout gnd 5p

.ends misc_gmc_filter

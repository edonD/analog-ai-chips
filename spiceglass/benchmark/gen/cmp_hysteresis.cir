.subckt cmp_hysteresis inp inn out vdd gnd
** Comparator with hysteresis (positive feedback on load)
** ===== Tail Current Source =====
Mtail tail vbias gnd gnd nmos W=20u L=1u
Mbias vbias vbias gnd gnd nmos W=2u L=1u
Rbias vdd vbias 60k
** ===== Input Pair =====
Min1 d1 inp tail gnd nmos W=12u L=0.5u
Min2 d2 inn tail gnd nmos W=12u L=0.5u
** ===== Hysteretic Load (cross-coupled + mirror) =====
Mlp1 d1 d2 vdd vdd pmos W=10u L=0.5u
Mlp2 d2 d1 vdd vdd pmos W=10u L=0.5u
Mlm1 d1 d1 vdd vdd pmos W=6u L=0.5u
Mlm2 d2 d2 vdd vdd pmos W=6u L=0.5u
** ===== Output Stage =====
Mop out d1 vdd vdd pmos W=24u L=0.35u
Mon out vbias gnd gnd nmos W=8u L=1u
.ends cmp_hysteresis

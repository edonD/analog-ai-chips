** Startup circuit + self-biased constant-gm core (defeats zero-current state)
.subckt ref_startup_bias vdd gnd vbiasn vbiasp

** ===== Self-Biased Core =====
* PMOS mirror (top) and NMOS pair with source-degen resistor (bottom)
M0 nl vbiasp vdd vdd pmos W=24u L=1u
M1 nr vbiasp vdd vdd pmos W=24u L=1u
M2 vbiasp nl vdd vdd pmos W=24u L=1u
M3 nl vbiasn gnd  gnd nmos W=6u  L=1u
M4 nr vbiasn gnd  gnd nmos W=48u L=1u
R0 nr_s gnd 4k
M5 vbiasn nr nr_s gnd nmos W=48u L=1u
R1 vbiasn nl 1

** ===== Startup =====
* Mst injects current when vbiasn is low; once core runs, Msw pulls gate to gnd
Msw nstart vbiasn gnd gnd nmos W=2u  L=4u
Mst vbiasp nstart vdd vdd pmos W=2u  L=8u
* High-resistance leg + cap establishes the startup node level
R2 vdd nstart 500k
M6 nstart nstart gnd gnd nmos W=1u L=4u
C0 nstart gnd 200f

.ends ref_startup_bias

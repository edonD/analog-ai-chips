.subckt ldo_ov_uv_protect vout vref ov_flag uv_flag gnd
** Over/under-voltage window comparator block monitoring vout
** ===== Sense Divider =====
Rs1     vout vsen 200k
Rs2     vsen gnd 100k
** ===== Reference Window (upper / lower thresholds) =====
Rwa     vref nhi 20k
Rwb     nhi nlo 10k
Rwc     nlo gnd 20k
** ===== OV Comparator (vsen > nhi) =====
Rtail1  vref t1 80k
Mova    o1 nhi t1 vref pmos W=15u L=0.5u
Movb    ov_raw vsen t1 vref pmos W=15u L=0.5u
Mol1    o1 o1 gnd gnd nmos W=8u L=0.5u
Mol2    ov_raw o1 gnd gnd nmos W=8u L=0.5u
Movinv  ov_flag ov_raw vref vref pmos W=6u L=0.5u
Movpd   ov_flag ov_raw gnd gnd nmos W=3u L=0.5u
** ===== UV Comparator (vsen < nlo) =====
Rtail2  vref t2 80k
Muva    u1 vsen t2 vref pmos W=15u L=0.5u
Muvb    uv_raw nlo t2 vref pmos W=15u L=0.5u
Mul1    u1 u1 gnd gnd nmos W=8u L=0.5u
Mul2    uv_raw u1 gnd gnd nmos W=8u L=0.5u
Muvinv  uv_flag uv_raw vref vref pmos W=6u L=0.5u
Muvpd   uv_flag uv_raw gnd gnd nmos W=3u L=0.5u
** ===== Hysteresis / Filter =====
Chyst   ov_raw gnd 0.5p
Cuvf    uv_raw gnd 0.5p
.ends ldo_ov_uv_protect

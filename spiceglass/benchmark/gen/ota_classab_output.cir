** Two-Stage OTA with Class-AB Push-Pull Output Stage
** Stage 1: PMOS input pair + NMOS mirror
** Output: complementary push-pull driven by floating-bias class-AB control
.subckt ota_classab_output inp inn out vdd gnd vbias vbn vbp

** ===== Tail =====
M0 tail vbias vdd vdd pmos W=80u L=1u

** ===== Differential Pair =====
M1 n1 inp tail vdd pmos W=40u L=0.5u
M2 n2 inn tail vdd pmos W=40u L=0.5u

** ===== Mirror Load =====
M3 n1 n1 gnd gnd nmos W=20u L=0.5u
M4 n2 n1 gnd gnd nmos W=20u L=0.5u

** ===== Class-AB Bias (floating battery) =====
M5 vgp vbp n2  vdd pmos W=20u L=0.5u
M6 vgn vbn vgp gnd nmos W=20u L=0.5u
M7 vgp vbias vdd vdd pmos W=30u L=1u
M8 vgn vbias gnd gnd nmos W=15u L=1u

** ===== Class-AB Output =====
M9  out vgp vdd vdd pmos W=200u L=0.5u
M10 out vgn gnd gnd nmos W=100u L=0.5u

** ===== Output Compensation =====
Cc1 n2 out 1.5p
Cc2 vgn out 1.5p

.ends ota_classab_output

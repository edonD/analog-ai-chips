** Sample-and-hold front end: CMOS transmission-gate switch + hold cap + buffer
** Clock/clockb drive the T-gate; source follower buffers the held voltage
.subckt misc_sample_hold vin vout clk clkb vbias vdd gnd

** ===== Sampling switch (CMOS transmission gate) =====
M1 vin clk vhold gnd nmos W=10u L=0.35u
M2 vin clkb vhold vdd pmos W=20u L=0.35u

** ===== Hold Cap =====
C1 vhold gnd 2p

** ===== Dummy switch (charge-injection cancel) =====
M3 vhold clkb vhold gnd nmos W=5u L=0.35u
M4 vhold clk vhold vdd pmos W=10u L=0.35u

** ===== Output buffer (source follower) =====
M5 vdd vhold vout vdd nmos W=40u L=0.5u
M6 vout vbias gnd gnd nmos W=20u L=1u
C2 vout gnd 500f

.ends misc_sample_hold

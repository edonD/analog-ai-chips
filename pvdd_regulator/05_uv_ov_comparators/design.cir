* Block 05: UV/OV Comparators
* PVDD 5V LDO Regulator — SkyWater SKY130A
*
* Topology: NMOS differential pair + PMOS mirror load, 1.8V supply domain
*   Resistive divider scales PVDD to ~1.226V at threshold crossing
*   Comparator core runs from vdd_comp (1.8V)
*   NOR gate output: flag = NOR(out_n, en_bar) for enable gating
*   Hysteresis via feedback resistor to divider midpoint
*
* Resistors: PDK xhigh_po (Rsh~2000 ohm/sq, TC1~-1.47e-3/C)
*   Divider R_top/R_bot are same type → ratio is 1st-order TC-insensitive
*
* Pin order for sky130 MOSFETs: D G S B
*
* ============================================================
* UV Comparator
* ============================================================
* Trips when PVDD falls below ~4.3V → uv_flag = HIGH
*
* Divider: Rtop=500k, Rbot=199.4k
*   ratio = 199.4/(500+199.4) = 0.28514 → trip at 4.299V
*
* Diff pair: M1(mid_uv) vs M2(vref)
*   out_n ∝ (mid_uv - vref) → LOW when UV
*   NOR(out_n_LOW, en_bar_LOW) = HIGH → uv_flag HIGH ✓
*
* Hysteresis: R_hyst from out_n to mid_uv
*   No UV → out_n HIGH → raises mid_uv → harder to trigger
*   UV    → out_n LOW  → lowers mid_uv → harder to de-assert
*
.subckt uv_comparator pvdd vref uv_flag vdd_comp gnd en

* --- Resistive divider (PDK xhigh_po, W=2u for matching) ---
XR_top pvdd mid_uv gnd sky130_fd_pr__res_xhigh_po w=2 l=500
XR_bot mid_uv gnd gnd sky130_fd_pr__res_xhigh_po w=2 l=199.4

* --- Hysteresis feedback (out_n to mid, W=1u for area) ---
XR_hyst out_n mid_uv gnd sky130_fd_pr__res_xhigh_po w=1 l=1250

* --- Bias current source (~1uA, PDK xhigh_po) ---
XR_bias vdd_comp bias_n gnd sky130_fd_pr__res_xhigh_po w=2 l=800
XMbias bias_n bias_n gnd gnd sky130_fd_pr__nfet_01v8 W=1u L=4u

* --- Tail current source (mirrors bias) ---
XMtail tail bias_n gnd gnd sky130_fd_pr__nfet_01v8 W=1u L=4u

* --- NMOS differential pair ---
XM1 out_p mid_uv tail gnd sky130_fd_pr__nfet_01v8 W=2u L=1u
XM2 out_n vref   tail gnd sky130_fd_pr__nfet_01v8 W=2u L=1u

* --- PMOS current mirror load ---
XM3 out_p out_p vdd_comp vdd_comp sky130_fd_pr__pfet_01v8 W=2u L=1u
XM4 out_n out_p vdd_comp vdd_comp sky130_fd_pr__pfet_01v8 W=2u L=1u

* --- Enable inversion: en → en_bar ---
XMen_n en_bar en gnd gnd sky130_fd_pr__nfet_01v8 W=0.42u L=0.15u
XMen_p en_bar en vdd_comp vdd_comp sky130_fd_pr__pfet_01v8 W=0.84u L=0.15u

* --- Output NOR gate: uv_flag = NOR(out_n, en_bar) ---
* PMOS in series (both must be OFF for output HIGH)
XMnor_p1 nor_mid out_n vdd_comp vdd_comp sky130_fd_pr__pfet_01v8 W=4u L=0.15u
XMnor_p2 uv_flag en_bar nor_mid  nor_mid  sky130_fd_pr__pfet_01v8 W=4u L=0.15u
* NMOS in parallel (either ON pulls output LOW)
XMnor_n1 uv_flag out_n  gnd gnd sky130_fd_pr__nfet_01v8 W=1u L=0.15u
XMnor_n2 uv_flag en_bar gnd gnd sky130_fd_pr__nfet_01v8 W=1u L=0.15u

.ends uv_comparator

* ============================================================
* OV Comparator
* ============================================================
* Trips when PVDD rises above ~5.5V → ov_flag = HIGH
*
* Divider: Rtop=500k, Rbot=143.4k
*   ratio = 143.4/(500+143.4) = 0.22282 → trip at 5.502V
*
* Diff pair: M1(vref) vs M2(mid_ov)
*   out_n ∝ (vref - mid_ov) → LOW when OV
*   NOR(out_n_LOW, en_bar_LOW) = HIGH → ov_flag HIGH ✓
*
* Hysteresis: R_hyst from ov_flag to mid_ov
*   No OV → ov_flag LOW → pulls mid_ov down → harder to trigger
*   OV    → ov_flag HIGH → pushes mid_ov up → harder to de-assert
*
.subckt ov_comparator pvdd vref ov_flag vdd_comp gnd en

* --- Resistive divider (PDK xhigh_po, W=2u for matching) ---
* Rbot increased from 143.4k to 146k to compensate hysteresis shift
XR_top pvdd mid_ov gnd sky130_fd_pr__res_xhigh_po w=2 l=500
XR_bot mid_ov gnd gnd sky130_fd_pr__res_xhigh_po w=2 l=146

* --- Hysteresis feedback (ov_flag to mid, W=1u for area) ---
XR_hyst ov_flag mid_ov gnd sky130_fd_pr__res_xhigh_po w=1 l=4000

* --- Bias current source (~1uA, PDK xhigh_po) ---
XR_bias vdd_comp bias_n gnd sky130_fd_pr__res_xhigh_po w=2 l=800
XMbias bias_n bias_n gnd gnd sky130_fd_pr__nfet_01v8 W=1u L=4u

* --- Tail current source ---
XMtail tail bias_n gnd gnd sky130_fd_pr__nfet_01v8 W=1u L=4u

* --- NMOS differential pair ---
* Note: inputs swapped vs UV (M1=vref, M2=mid_ov)
XM1 out_p vref   tail gnd sky130_fd_pr__nfet_01v8 W=2u L=1u
XM2 out_n mid_ov tail gnd sky130_fd_pr__nfet_01v8 W=2u L=1u

* --- PMOS current mirror load ---
XM3 out_p out_p vdd_comp vdd_comp sky130_fd_pr__pfet_01v8 W=2u L=1u
XM4 out_n out_p vdd_comp vdd_comp sky130_fd_pr__pfet_01v8 W=2u L=1u

* --- Enable inversion ---
XMen_n en_bar en gnd gnd sky130_fd_pr__nfet_01v8 W=0.42u L=0.15u
XMen_p en_bar en vdd_comp vdd_comp sky130_fd_pr__pfet_01v8 W=0.84u L=0.15u

* --- Output NOR gate: ov_flag = NOR(out_n, en_bar) ---
XMnor_p1 nor_mid out_n vdd_comp vdd_comp sky130_fd_pr__pfet_01v8 W=4u L=0.15u
XMnor_p2 ov_flag en_bar nor_mid  nor_mid  sky130_fd_pr__pfet_01v8 W=4u L=0.15u
XMnor_n1 ov_flag out_n  gnd gnd sky130_fd_pr__nfet_01v8 W=1u L=0.15u
XMnor_n2 ov_flag en_bar gnd gnd sky130_fd_pr__nfet_01v8 W=1u L=0.15u

.ends ov_comparator

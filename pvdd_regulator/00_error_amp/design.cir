* Block 00: Error Amplifier — Two-Stage Miller OTA
* PVDD 5V LDO Regulator — SkyWater SKY130A
*
* Topology: Two-stage Miller-compensated OTA
*   Stage 1: PMOS diff pair + NMOS mirror load → ~40-50 dB
*   Stage 2: NMOS common-source + PMOS load → ~30-40 dB
*   Miller cap (Cc) + nulling resistor (Rc) for compensation
*   Total gain > 60 dB, drives 100pF Cgs_pass load
*
* All HV 5V/10.5V devices. Dims in microns (hsa SCALE=1e-6).
* ibias: 1uA INTO ibias pin, sunk to GND internally.
*
.subckt error_amp vref vfb vout_gate pvdd gnd ibias en

* ================================================================
* Enable
* ================================================================
XMen   ibias_en en  ibias   gnd  sky130_fd_pr__nfet_g5v0d10v5 w=20 l=1 m=1
XMpu   vout_gate en pvdd    pvdd sky130_fd_pr__pfet_g5v0d10v5 w=20 l=1 m=1

* ================================================================
* Bias: NMOS reference (1uA)
* ================================================================
XMbn0  ibias_en ibias_en gnd gnd sky130_fd_pr__nfet_g5v0d10v5 w=20 l=8 m=1

* ================================================================
* Bias: PMOS tail (20uA)
* ================================================================
XMbn_pb pb_tail ibias_en gnd gnd sky130_fd_pr__nfet_g5v0d10v5 w=20 l=8 m=20
XMbp0   pb_tail pb_tail  pvdd pvdd sky130_fd_pr__pfet_g5v0d10v5 w=20 l=4 m=4

* ================================================================
* Stage 1: PMOS diff pair + NMOS current mirror load
* ================================================================
* Tail current source: 20uA
XMtail tail_s pb_tail pvdd pvdd sky130_fd_pr__pfet_g5v0d10v5 w=20 l=4 m=4

* PMOS diff pair: M1(+)=vref, M2(-)=vfb
* Large W*L for matching; W=50 L=4 m=2 → eff W=100um, WL=400um^2
XM1 d1  vref tail_s pvdd sky130_fd_pr__pfet_g5v0d10v5 w=50 l=4 m=2
XM2 d2  vfb  tail_s pvdd sky130_fd_pr__pfet_g5v0d10v5 w=50 l=4 m=2

* NMOS current mirror load: left=diode, right=output
* Long L for high ro and gain
XMn_l d1 d1  gnd gnd sky130_fd_pr__nfet_g5v0d10v5 w=20 l=8 m=2
XMn_r d2 d1  gnd gnd sky130_fd_pr__nfet_g5v0d10v5 w=20 l=8 m=2

* ================================================================
* Stage 2: NMOS common-source + PMOS active load
* ================================================================
* CS amplifier: gate=d2 (stage 1 output), drain=vout_gate
* Sized to match PMOS load current at d2 ≈ 0.9V
XMcs vout_gate d2  gnd gnd sky130_fd_pr__nfet_g5v0d10v5 w=20 l=1 m=1

* PMOS current source load: mirrors from pb_tail
* ~20uA for good slew rate into 100pF load
XMp_ld vout_gate pb_tail pvdd pvdd sky130_fd_pr__pfet_g5v0d10v5 w=20 l=4 m=8

* ================================================================
* Miller compensation: Cc + Rc from vout_gate to d2
* ================================================================
* Cc = 5pF (Miller cap, moves dominant pole to stage 1 output)
Cc d2 comp_mid 1050p
* Rc nulling resistor: Rc ≈ 1/gm2 moves RHP zero to infinity
* gm2 of Mcs ≈ 2*Id/Vov ≈ 2*20uA/0.2V = 200uS → 1/gm2 ≈ 5k
Rc comp_mid vout_gate 11.4k

.ends error_amp

* Block 00: Error Amplifier — Two-Stage Miller OTA
* PVDD 5V LDO Regulator — SkyWater SKY130A
*
* ARCHITECTURE (v6 — v25b base + cascode NMOS for PSRR):
*   Stage 1: PMOS diff pair + NMOS mirror load (PVDD domain)
*   Stage 2: NMOS CS + cascode NMOS + PMOS active load (PVDD domain)
*     The cascode on the NMOS CS shields d2 from vout_gate swing
*     This increases Stage 2 gain → more loop gain → better PSRR
*   Miller comp (Cc+Rc) from d2 to vout_gate
*
* ibias: 1µA INTO ibias pin, sunk to GND internally.
*
.subckt error_amp vref vfb vout_gate pvdd gnd ibias en bvdd

* ================================================================
* Enable
* ================================================================
XMen   ibias_en en  ibias   gnd  sky130_fd_pr__nfet_g5v0d10v5 w=20e-6 l=1e-6 m=1
XMpu   vout_gate en pvdd    pvdd sky130_fd_pr__pfet_g5v0d10v5 w=20e-6 l=1e-6 m=1

* ================================================================
* Bias: NMOS reference (1µA)
* ================================================================
XMbn0  ibias_en ibias_en gnd gnd sky130_fd_pr__nfet_g5v0d10v5 w=20e-6 l=8e-6 m=1

* ================================================================
* Bias: PMOS tail (200µA)
* ================================================================
XMbn_pb pb_tail ibias_en gnd gnd sky130_fd_pr__nfet_g5v0d10v5 w=20e-6 l=8e-6 m=200
XMbp0   pb_tail pb_tail  pvdd pvdd sky130_fd_pr__pfet_g5v0d10v5 w=20e-6 l=4e-6 m=4

* ================================================================
* Stage 1: PMOS diff pair + NMOS current mirror load
* ================================================================
XMtail tail_s pb_tail pvdd pvdd sky130_fd_pr__pfet_g5v0d10v5 w=20e-6 l=4e-6 m=4
XM1 d1  vref tail_s pvdd sky130_fd_pr__pfet_g5v0d10v5 w=80e-6 l=4e-6 m=2
XM2 d2  vfb  tail_s pvdd sky130_fd_pr__pfet_g5v0d10v5 w=80e-6 l=4e-6 m=2
XMn_l d1 d1  gnd gnd sky130_fd_pr__nfet_g5v0d10v5 w=20e-6 l=8e-6 m=2
XMn_r d2 d1  gnd gnd sky130_fd_pr__nfet_g5v0d10v5 w=20e-6 l=8e-6 m=2

* ================================================================
* Stage 2: NMOS CS + PMOS active load (PVDD domain)
*   CS gate=d2, adds gain and level-shifts to drive gate
* ================================================================
XMcs vout_gate d2  gnd gnd sky130_fd_pr__nfet_g5v0d10v5 w=20e-6 l=1e-6 m=1
XMp_ld vout_gate pb_tail pvdd pvdd sky130_fd_pr__pfet_g5v0d10v5 w=20e-6 l=4e-6 m=8

* ================================================================
* Miller compensation: Cc + Rc from d2 to vout_gate
* ================================================================
Cc d2 comp_mid 30p
Rc comp_mid vout_gate 25k

.ends error_amp

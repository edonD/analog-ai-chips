* tb_ea_offset.spice — Input offset voltage measurement
* Block 00: Error Amplifier
*
* Method: Close a unity-gain feedback loop around the OTA.
* Apply vref=1.226V, measure vfb at equilibrium. Offset = vfb - vref.
* Use a large resistor for DC feedback to avoid loading issues.

.lib "/home/ubuntu/.volare/volare/sky130/versions/0fe599b2afb6708d281543108caf8310912f54af/sky130A/libs.tech/ngspice/sky130.lib.spice" tt
.include "design.cir"

* --- Supplies and references ---
Vpvdd pvdd 0 DC 5.0
Vref  vref 0 DC 1.226
Ven   en   0 DC 5.0
Ibias pvdd ibias DC 1u

* --- DUT in unity-gain feedback ---
* Connect output back to vfb through large resistor (DC feedback)
* Small cap at vfb for stability
Xea vref vfb vout_gate pvdd 0 ibias en error_amp

Rfb vout_gate vfb 10Meg
Cfb vfb 0 1p

* Load
Cload vout_gate 0 100p

* --- Simulation ---
.control
  * Use transient to let the feedback loop settle
  tran 1u 5m uic

  * Measure settled value of vfb
  let vfb_settled = v(vfb)[length(v(vfb))-1]
  let vref_val = 1.226
  let offset_v = vfb_settled - vref_val
  let offset_mv = offset_v * 1000
  let offset_abs = abs(offset_mv)

  echo "=== Input Offset ==="
  print vfb_settled offset_mv

  echo "input_offset_mV: $&offset_abs"

  quit
.endc

.end

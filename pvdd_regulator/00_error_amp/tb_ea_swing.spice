* tb_ea_swing.spice — Output voltage swing verification
* Block 00: Error Amplifier
*
* Sweep differential input to drive output from rail to rail.
* Measure min and max output voltage.

.lib "/home/ubuntu/.volare/volare/sky130/versions/0fe599b2afb6708d281543108caf8310912f54af/sky130A/libs.tech/ngspice/sky130.lib.spice" tt
.include "design.cir"

* --- Supplies and references ---
Vpvdd pvdd 0 DC 5.0
Ven   en   0 DC 5.0
Ibias pvdd ibias DC 1u

* --- Inputs: sweep vfb while holding vref fixed ---
* When vfb > vref: output should go high (PMOS input, inverting from vfb)
* When vfb < vref: output should go low
Vref  vref 0 DC 1.226
Vfb   vfb  0 DC 1.226

* --- DUT ---
Xea vref vfb vout_gate pvdd 0 ibias en error_amp

* --- Light load only (no Cload for DC sweep) ---
Rload vout_gate 0 100Meg

* --- Simulation ---
.control
  * DC sweep: vary vfb around vref
  dc Vfb 0.8 1.6 0.001

  let vout = v(vout_gate)
  let vout_min = vecmin(vout)
  let vout_max = vecmax(vout)

  echo "=== Output Swing ==="
  print vout_min vout_max

  echo "output_swing_low: $&vout_min"
  echo "output_swing_high: $&vout_max"

  * Save for plotting
  wrdata swing.dat v(vout_gate)

  quit
.endc

.end

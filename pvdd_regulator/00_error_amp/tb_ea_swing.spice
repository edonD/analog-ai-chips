* tb_ea_swing.spice — Output voltage swing
* Block 00: Error Amplifier (Two-Stage Miller OTA)

.lib "/home/ubuntu/.volare/volare/sky130/versions/0fe599b2afb6708d281543108caf8310912f54af/sky130A/libs.tech/ngspice/sky130.lib.spice" tt
.include "design.cir"

Vpvdd pvdd 0 DC 5.0
Ven   en   0 DC 5.0
Ibias pvdd ibias DC 1u

Vref  vref 0 DC 1.226
Vfb   vfb  0 DC 1.226

Xea vref vfb vout_gate pvdd 0 ibias en error_amp
Rload vout_gate 0 100Meg

.control
  dc Vfb 0.5 2.0 0.001

  let vout = v(vout_gate)
  let vout_min = vecmin(vout)
  let vout_max = vecmax(vout)

  echo "output_swing_low: $&vout_min"
  echo "output_swing_high: $&vout_max"

  wrdata swing.dat v(vout_gate)
  quit
.endc

.end

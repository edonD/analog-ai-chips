* tb_ea_psrr.spice — Power Supply Rejection Ratio
* Block 00: Error Amplifier
*
* Method: Apply AC signal on PVDD supply, measure at output.
* PSRR = Adm / Aps, or PSRR_dB = Adm_dB - Aps_dB
* Aps = Vout_gate / Vpvdd_ac

.lib "/home/ubuntu/.volare/volare/sky130/versions/0fe599b2afb6708d281543108caf8310912f54af/sky130A/libs.tech/ngspice/sky130.lib.spice" tt
.include "design.cir"

* --- Supply with AC perturbation ---
Vpvdd pvdd 0 DC 5.0 AC 1

* --- Fixed inputs ---
Vref  vref 0 DC 1.226
Vfb   vfb  0 DC 1.226
Ven   en   0 DC 5.0
Ibias pvdd ibias DC 1u

* --- DUT ---
Xea vref vfb vout_gate pvdd 0 ibias en error_amp
Cload vout_gate 0 100p

* --- Simulation ---
.control
  ac dec 50 10 10Meg

  * Supply gain: Vout/Vpvdd_ac
  let aps = abs(v(vout_gate))
  let aps_db = 20*log10(aps)
  let aps_dc = aps_db[0]

  echo "=== PSRR Measurement ==="
  echo "Supply gain at DC (dB):"
  print aps_dc

  echo "aps_dc_dB: $&aps_dc"

  * Save for plotting
  wrdata psrr.dat aps_db

  quit
.endc

.end

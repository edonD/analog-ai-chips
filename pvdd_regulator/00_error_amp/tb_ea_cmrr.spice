* tb_ea_cmrr.spice — Common-mode rejection ratio
* Block 00: Error Amplifier (Two-Stage Miller OTA)

.lib "/home/ubuntu/.volare/volare/sky130/versions/0fe599b2afb6708d281543108caf8310912f54af/sky130A/libs.tech/ngspice/sky130.lib.spice" tt
.include "design.cir"

Vpvdd pvdd 0 DC 5.0
Ven   en   0 DC 5.0
Ibias pvdd ibias DC 1u

* Common-mode AC on both inputs
Vcm  cm  0 DC 1.226 AC 1
Rvref cm vref 1
Rvfb  cm vfb  1

Xea vref vfb vout_gate pvdd 0 ibias en error_amp
Cload vout_gate 0 100p

.nodeset v(vout_gate)=2.5

.control
  ac dec 50 10 10Meg

  let acm = abs(v(vout_gate))
  let acm_db = 20*log10(acm)
  let acm_dc = acm_db[0]

  echo "acm_dc_dB: $&acm_dc"
  quit
.endc

.end

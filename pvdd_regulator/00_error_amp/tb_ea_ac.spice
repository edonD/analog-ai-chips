* tb_ea_ac.spice — Open-loop gain, UGB, phase margin
* Block 00: Error Amplifier (Two-Stage Miller OTA)
*
* Method: AC stimulus at vfb, measure gain = -v(vout_gate)/v(vfb)
* DC feedback via large resistor to set operating point

.lib "/home/ubuntu/.volare/volare/sky130/versions/0fe599b2afb6708d281543108caf8310912f54af/sky130A/libs.tech/ngspice/sky130.lib.spice" tt
.include "design.cir"

Vpvdd pvdd 0 DC 5.0
Vref  vref 0 DC 1.226
Ven   en   0 DC 5.0
Ibias pvdd ibias DC 1u

* AC source at vfb with DC feedback for bias
Vfb   vfb_ac  0 DC 1.226 AC 1
Rfb_dc vout_gate vfb_ac 100Meg

Xea vref vfb_ac vout_gate pvdd 0 ibias en error_amp
Cload vout_gate 0 100p

.nodeset v(vout_gate)=2.5

.control
  op
  ac dec 100 10 100Meg

  * Gain and phase (inverting: vfb is neg input)
  let gain_mag = abs(v(vout_gate))
  let gain_db = 20*log10(gain_mag)
  let phase_raw = 180/PI * cph(v(vout_gate))

  let dc_gain = gain_db[0]
  echo "=== AC Results ==="
  echo "dc_gain: $&dc_gain"

  * Find UGB: scan for first 0dB crossing
  let n = length(gain_db)
  let ugb_hz = 0
  let pm_deg = 0
  let i = 1
  let prev_g = gain_db[0]
  repeat $&n
    if prev_g > 0
      if gain_db[i] <= 0
        let ugb_hz = frequency[i]
        let pm_deg = phase_raw[i] + 180
        * Break by setting prev_g negative
        let prev_g = -1
      end
    end
    if prev_g >= 0
      let prev_g = gain_db[i]
    end
    let i = i + 1
  end

  let ugb_khz = ugb_hz / 1000
  echo "ugb_kHz: $&ugb_khz"
  echo "phase_margin: $&pm_deg"

  wrdata ac_gain.dat gain_db phase_raw
  quit
.endc

.end

* tb_ea_noise.spice — Input-referred noise analysis
* Block 00: Error Amplifier (Two-Stage Miller OTA)
* Method: Use .noise with Vfb as input source (must have AC 1)
*   .noise measures output noise and divides by gain to get input-referred
*   Use inductor for DC feedback to avoid resistor noise contribution

* design_noise.cir adds nrd=0.1 nrs=0.1 to all device instances, providing
* ngspice with nonzero S/D parasitic resistance and eliminating the spurious
* "conductance reset to 1.0e3 mho" warnings during noise analysis.
* DC impact: negligible (0.1 ohm * 20uA = 2 uV drop per terminal).
.lib "/home/ubuntu/.volare/volare/sky130/versions/0fe599b2afb6708d281543108caf8310912f54af/sky130A/libs.tech/ngspice/sky130.lib.spice" tt
.include "design_noise.cir"

Vpvdd pvdd 0 DC 5.0
Vref  vref 0 DC 1.226
Ven   en   0 DC 5.0
Ibias pvdd ibias DC 1u

* Input source — MUST have AC 1 for .noise to work
Vfb   vfb  0 DC 1.226 AC 1

* DC feedback using inductor (no noise, low impedance at DC, high at AC)
Lfb   vout_gate vfb 1G

Xea vref vfb vout_gate pvdd 0 ibias en error_amp
Cload vout_gate 0 100p

.nodeset v(vout_gate)=2.5

.option gmin=1e-12 reltol=1e-4

.control
  * First verify operating point converges
  op

  echo "=== Noise Analysis ==="

  * Run noise analysis: output = v(vout_gate), input source = Vfb
  noise v(vout_gate) Vfb dec 50 10 1Meg

  * noise1 = Spectral Density, noise2 = Integrated totals
  * Write spectral data for plotting
  setplot noise1
  wrdata noise_spectral.dat inoise_spectrum

  * Switch to integrated noise results
  setplot noise2
  let inoise_uv = inoise_total * 1e6
  echo "inoise_total_uVrms: $&inoise_uv"

  echo "noise_analysis: done"
  quit
.endc

.end

* tb_ea_noise.spice — Noise analysis
* Block 00: Error Amplifier (Two-Stage Miller OTA)

.lib "/home/ubuntu/.volare/volare/sky130/versions/0fe599b2afb6708d281543108caf8310912f54af/sky130A/libs.tech/ngspice/sky130.lib.spice" tt
.include "design.cir"

Vpvdd pvdd 0 DC 5.0
Vref  vref 0 DC 1.226
Ven   en   0 DC 5.0
Ibias pvdd ibias DC 1u
Vfb   vfb  0 DC 1.226

Xea vref vfb vout_gate pvdd 0 ibias en error_amp
Cload vout_gate 0 100p

.nodeset v(vout_gate)=2.5

.control
  noise v(vout_gate) Vfb dec 50 10 1Meg

  setplot noise2
  let inoise_uv = inoise_total * 1e6
  echo "inoise_total_uVrms: $&inoise_uv"
  echo "noise_analysis: done"

  quit
.endc

.end

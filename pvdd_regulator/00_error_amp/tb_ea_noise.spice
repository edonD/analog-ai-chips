* tb_ea_noise.spice — Output noise spectral density and integrated noise
* Block 00: Error Amplifier

.lib "/home/ubuntu/.volare/volare/sky130/versions/0fe599b2afb6708d281543108caf8310912f54af/sky130A/libs.tech/ngspice/sky130.lib.spice" tt
.include "design.cir"

* --- Supplies and references ---
Vpvdd pvdd 0 DC 5.0
Vref  vref 0 DC 1.226
Ven   en   0 DC 5.0
Ibias pvdd ibias DC 1u

* --- Input: AC source at vfb for noise reference ---
Vfb   vfb  0 DC 1.226

* --- DUT ---
Xea vref vfb vout_gate pvdd 0 ibias en error_amp
Cload vout_gate 0 100p

* --- Simulation ---
.control
  * Noise analysis: output at vout_gate, input reference Vfb
  noise v(vout_gate) Vfb dec 50 10 1Meg

  * The noise analysis produces onoise_spectrum and inoise_spectrum
  setplot noise1
  let onoise = onoise_spectrum
  let inoise = inoise_spectrum

  * Save noise data for plotting
  wrdata noise.dat onoise inoise

  * Print noise at key frequencies
  * Integrated noise will be computed from the spectrum

  echo "=== Noise Analysis ==="
  echo "noise_analysis: done"

  setplot noise2
  print onoise_total
  print inoise_total
  let inoise_uv = inoise_total * 1e6
  echo "inoise_total_uVrms: $&inoise_uv"

  quit
.endc

.end

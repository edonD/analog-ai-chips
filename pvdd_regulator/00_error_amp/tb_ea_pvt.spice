* tb_ea_pvt.spice — PVT corner sweep (TT only, shell runs all corners)
* Block 00: Error Amplifier (Two-Stage Miller OTA)

.lib "/home/ubuntu/.volare/volare/sky130/versions/0fe599b2afb6708d281543108caf8310912f54af/sky130A/libs.tech/ngspice/sky130.lib.spice" tt
.include "design.cir"

Vpvdd pvdd 0 DC 5.0
Vref  vref 0 DC 1.226
Ven   en   0 DC 5.0
Ibias pvdd ibias DC 1u

Vfb   vfb_ac  0 DC 1.226 AC 1
Rfb_dc vout_gate vfb_ac 100Meg

Xea vref vfb_ac vout_gate pvdd 0 ibias en error_amp
Cload vout_gate 0 100p

.nodeset v(vout_gate)=2.5

.control
  let all_pass = 1

  foreach temp_val -40 27 150
    set temp = $temp_val
    op
    ac dec 100 10 100Meg

    let gdb = 20*log10(abs(v(vout_gate)))
    let ph = 180/PI * cph(v(vout_gate))
    let dc_g = gdb[0]

    let n = length(gdb)
    let found = 0
    let pm = 0
    let i = 1
    let prev = gdb[0]
    repeat $&n
      if found = 0
        if prev > 0
          if gdb[i] <= 0
            let pm = ph[i] + 180
            let found = 1
          end
        end
      end
      if found = 0
        let prev = gdb[i]
      end
      let i = i + 1
    end

    echo "PVT TT $temp_val C: gain=$&dc_g dB, PM=$&pm deg"

    if dc_g < 60
      let all_pass = 0
    end
    if pm < 55
      if pm > 0
        let all_pass = 0
      end
    end

    destroy all
  end

  echo "pvt_all_pass: $&all_pass"
  quit
.endc

.end

* tb_ea_dc.spice — DC operating point, saturation check, Iq
* Block 00: Error Amplifier (Two-Stage Miller OTA)

.lib "/home/ubuntu/.volare/volare/sky130/versions/0fe599b2afb6708d281543108caf8310912f54af/sky130A/libs.tech/ngspice/sky130.lib.spice" tt
.include "design.cir"

Vpvdd pvdd 0 DC 5.0
Vref  vref 0 DC 1.226
Vfb   vfb  0 DC 1.226
Ven   en   0 DC 5.0
Ibias pvdd ibias DC 1u

Xea vref vfb vout_gate pvdd 0 ibias en error_amp
Cload vout_gate 0 100p

.nodeset v(vout_gate)=2.5 v(xea.d2)=0.9

.option savecurrents
.control
  op

  echo "=== DC Operating Point ==="
  print v(vout_gate) v(xea.tail_s) v(xea.d1) v(xea.d2) v(xea.pb_tail)

  * Quiescent current
  let iq = -i(vpvdd)
  let iq_ua = iq * 1e6
  echo "iq_uA: $&iq_ua"

  * Saturation check: verify key nodes in reasonable range
  let vout = v(vout_gate)
  let vd2 = v(xea.d2)
  let sat_ok = 1

  * Stage 1 output (d2) should be around 0.8-1.5V for NMOS mirror
  if vd2 < 0.3
    let sat_ok = 0
  end
  if vd2 > 3.0
    let sat_ok = 0
  end

  echo "devices_in_sat: $&sat_ok"

  quit
.endc

.end

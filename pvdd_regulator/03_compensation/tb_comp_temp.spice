* tb_comp_temp.spice — Temperature sweep at TT corner
* Tests PM at -40C, 27C, 150C at 10mA load

* Parasitic model for poly resistor
.subckt sky130_fd_pr__model__parasitic__res_po r0 r1 sub w=1 l=1
c0 r0 sub 0.05f
c1 r1 sub 0.05f
.ends sky130_fd_pr__model__parasitic__res_po

.lib "../sky130.lib.spice" tt

.include "../00_error_amp/design.cir"
.include "../01_pass_device/design.cir"
.include "design.cir"

* Supplies
Vbvdd bvdd 0 DC 7.0
Vavbg avbg 0 DC 1.226
Ven   en   0 DC 5.0
Ibias bvdd ibias DC 1u

* Error amplifier
Xea avbg vfb vout_gate bvdd 0 ibias en error_amp

* Compensation
Xcomp vout_gate pvdd 0 compensation

* Pass device
Xpass vout_gate bvdd pvdd pass_device

* Load: 10mA
Cload pvdd 0 200p
Rload pvdd 0 500

* Feedback divider + loop break
Rtop pvdd vfb_dc 314.75k
Rbot vfb_dc 0 102.25k
Rdc vfb_dc vfb 100Meg
Cinj ac_src vfb 1
Vac ac_src 0 AC 1

.nodeset v(pvdd)=5.0 v(vout_gate)=5.5 v(vfb)=1.226
.option reltol=1e-4 abstol=1e-12 vntol=1e-6 gmin=1e-12

.control
  let beta = 0.2452

  foreach temp_val -40 27 150
    set temp = $temp_val
    op
    ac dec 200 1 100Meg

    let T_db = 20*log10(abs(v(pvdd))+1e-30) + 20*log10(beta)
    let T_ph = 180/PI * cph(v(pvdd)) + 180
    let npts = length(T_db)
    let i = 0
    dowhile i < npts
      if T_ph[i] > 180
        let T_ph[i] = T_ph[i] - 360
      end
      let i = i + 1
    end

    let ugb = 0
    let pm = 0
    let i = 1
    dowhile i < npts
      if ugb = 0
        if T_db[i-1] > 0
          if T_db[i] <= 0
            let ugb = frequency[i]
            let pm = T_ph[i] + 180
          end
        end
      end
      let i = i + 1
    end

    echo "temp=$temp_val PM=$&pm UGB=$&ugb"
    destroy all
  end

  quit
.endc

.end

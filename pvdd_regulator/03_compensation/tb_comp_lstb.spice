* tb_comp_lstb.spice — Loop Stability at 5 load points
* Full LDO loop with real Block 02 feedback network
* Method: DC-closed (100M), AC-open, injection through 1F cap

* Parasitic model for poly resistor
.subckt sky130_fd_pr__model__parasitic__res_po r0 r1 sub w=1 l=1
c0 r0 sub 0.05f
c1 r1 sub 0.05f
.ends sky130_fd_pr__model__parasitic__res_po

.lib "../sky130.lib.spice" tt
.temp 27

.include "../00_error_amp/design.cir"
.include "../01_pass_device/design.cir"
.include "../02_feedback_network/design.cir"
.include "design.cir"

* Supplies
Vbvdd bvdd 0 DC 7.0
Vavbg avbg 0 DC 1.226
Ven   en   0 DC 5.0
Ibias bvdd ibias DC 1u

* Error amplifier (supplied from bvdd)
Xea avbg vfb vout_gate bvdd 0 ibias en error_amp

* Compensation
Xcomp vout_gate pvdd 0 compensation

* Pass device
Xpass vout_gate bvdd pvdd pass_device

* Load
Cload pvdd 0 200p
Rload pvdd 0 rload_ohm
.param rload_ohm = 500

* Real feedback divider (Block 02) + loop break
* The feedback network connects pvdd → vfb_div → gnd
Xfb pvdd vfb_div 0 feedback_network

* DC loop closure through high R, AC injection through cap
Rdc vfb_div vfb 100Meg
Cinj ac_src vfb 1
Vac ac_src 0 AC 1

.nodeset v(pvdd)=5.0 v(vout_gate)=5.5 v(vfb)=1.226
.option reltol=1e-4 abstol=1e-12 vntol=1e-6 gmin=1e-12

.control
  let beta = 0.2452
  let pm_min = 999
  let gm_min = 999

  * ==== 0 mA (Rload=10G) ====
  alterparam rload_ohm = 10G
  reset
  op
  ac dec 200 1 100Meg
  let T_db = 20*log10(abs(v(pvdd))+1e-30) + 20*log10(beta)
  let T_ph = 180/PI * cph(v(pvdd)) + 180
  let npts = length(T_db)
  let i = 0
  dowhile i < npts
    if T_ph[i] > 180
      let T_ph[i] = T_ph[i] - 360
    end
    let i = i + 1
  end
  let ugb = 0
  let pm = 0
  let gm_v = 100
  let i = 1
  dowhile i < npts
    if ugb = 0
      if T_db[i-1] > 0
        if T_db[i] <= 0
          let ugb = frequency[i]
          let pm = T_ph[i] + 180
        end
      end
    end
    let i = i + 1
  end
  let i = 1
  dowhile i < npts
    if gm_v > 99
      if T_ph[i-1] > -180
        if T_ph[i] <= -180
          let gm_v = -T_db[i]
        end
      end
    end
    let i = i + 1
  end
  echo "pm_0mA_deg: $&pm"
  echo "gm_0mA_dB: $&gm_v"
  let ugb_k = ugb/1000
  echo "ugb_0mA_kHz: $&ugb_k"
  if pm < pm_min
    let pm_min = pm
  end
  if gm_v < gm_min
    let gm_min = gm_v
  end
  destroy all

  * ==== 100 uA (Rload=50k) ====
  alterparam rload_ohm = 50k
  reset
  op
  ac dec 200 1 100Meg
  let T_db = 20*log10(abs(v(pvdd))+1e-30) + 20*log10(0.2452)
  let T_ph = 180/PI * cph(v(pvdd)) + 180
  let npts = length(T_db)
  let i = 0
  dowhile i < npts
    if T_ph[i] > 180
      let T_ph[i] = T_ph[i] - 360
    end
    let i = i + 1
  end
  let ugb = 0
  let pm = 0
  let gm_v = 100
  let i = 1
  dowhile i < npts
    if ugb = 0
      if T_db[i-1] > 0
        if T_db[i] <= 0
          let ugb = frequency[i]
          let pm = T_ph[i] + 180
        end
      end
    end
    let i = i + 1
  end
  let i = 1
  dowhile i < npts
    if gm_v > 99
      if T_ph[i-1] > -180
        if T_ph[i] <= -180
          let gm_v = -T_db[i]
        end
      end
    end
    let i = i + 1
  end
  echo "pm_100uA_deg: $&pm"
  echo "gm_100uA_dB: $&gm_v"
  if pm < pm_min
    let pm_min = pm
  end
  if gm_v < gm_min
    let gm_min = gm_v
  end
  destroy all

  * ==== 1 mA (Rload=5k) ====
  alterparam rload_ohm = 5k
  reset
  op
  ac dec 200 1 100Meg
  let T_db = 20*log10(abs(v(pvdd))+1e-30) + 20*log10(0.2452)
  let T_ph = 180/PI * cph(v(pvdd)) + 180
  let npts = length(T_db)
  let i = 0
  dowhile i < npts
    if T_ph[i] > 180
      let T_ph[i] = T_ph[i] - 360
    end
    let i = i + 1
  end
  let ugb = 0
  let pm = 0
  let gm_v = 100
  let i = 1
  dowhile i < npts
    if ugb = 0
      if T_db[i-1] > 0
        if T_db[i] <= 0
          let ugb = frequency[i]
          let pm = T_ph[i] + 180
        end
      end
    end
    let i = i + 1
  end
  let i = 1
  dowhile i < npts
    if gm_v > 99
      if T_ph[i-1] > -180
        if T_ph[i] <= -180
          let gm_v = -T_db[i]
        end
      end
    end
    let i = i + 1
  end
  echo "pm_1mA_deg: $&pm"
  echo "gm_1mA_dB: $&gm_v"
  if pm < pm_min
    let pm_min = pm
  end
  if gm_v < gm_min
    let gm_min = gm_v
  end
  destroy all

  * ==== 10 mA (Rload=500) ====
  alterparam rload_ohm = 500
  reset
  op
  ac dec 200 1 100Meg
  let T_db = 20*log10(abs(v(pvdd))+1e-30) + 20*log10(0.2452)
  let T_ph = 180/PI * cph(v(pvdd)) + 180
  let npts = length(T_db)
  let i = 0
  dowhile i < npts
    if T_ph[i] > 180
      let T_ph[i] = T_ph[i] - 360
    end
    let i = i + 1
  end
  let ugb = 0
  let pm = 0
  let gm_v = 100
  let i = 1
  dowhile i < npts
    if ugb = 0
      if T_db[i-1] > 0
        if T_db[i] <= 0
          let ugb = frequency[i]
          let pm = T_ph[i] + 180
        end
      end
    end
    let i = i + 1
  end
  let i = 1
  dowhile i < npts
    if gm_v > 99
      if T_ph[i-1] > -180
        if T_ph[i] <= -180
          let gm_v = -T_db[i]
        end
      end
    end
    let i = i + 1
  end
  echo "pm_10mA_deg: $&pm"
  echo "gm_10mA_dB: $&gm_v"
  if pm < pm_min
    let pm_min = pm
  end
  if gm_v < gm_min
    let gm_min = gm_v
  end
  destroy all

  * ==== 50 mA (Rload=100) ====
  alterparam rload_ohm = 100
  reset
  op
  ac dec 200 1 100Meg
  let T_db = 20*log10(abs(v(pvdd))+1e-30) + 20*log10(0.2452)
  let T_ph = 180/PI * cph(v(pvdd)) + 180
  let npts = length(T_db)
  let i = 0
  dowhile i < npts
    if T_ph[i] > 180
      let T_ph[i] = T_ph[i] - 360
    end
    let i = i + 1
  end
  let ugb = 0
  let pm = 0
  let gm_v = 100
  let i = 1
  dowhile i < npts
    if ugb = 0
      if T_db[i-1] > 0
        if T_db[i] <= 0
          let ugb = frequency[i]
          let pm = T_ph[i] + 180
        end
      end
    end
    let i = i + 1
  end
  let i = 1
  dowhile i < npts
    if gm_v > 99
      if T_ph[i-1] > -180
        if T_ph[i] <= -180
          let gm_v = -T_db[i]
        end
      end
    end
    let i = i + 1
  end
  echo "pm_50mA_deg: $&pm"
  echo "gm_50mA_dB: $&gm_v"
  if pm < pm_min
    let pm_min = pm
  end
  if gm_v < gm_min
    let gm_min = gm_v
  end
  destroy all

  * Summary
  echo "pm_min_deg: $&pm_min"
  echo "gm_min_dB: $&gm_min"

  quit
.endc

.end

* Block 03: Compensation Network
* PVDD 5V LDO Regulator — SkyWater SKY130A
*
* Topology: Miller Cc + Rz from vout_gate to pvdd + output Cout
*   Cc: 50 pF MIM cap (Miller pole-splitting)
*   Rz: 4.5 kΩ xhigh poly (LHP zero at ~707 kHz)
*   Cout: 50 pF MIM cap (output decoupling, improves PM)
*
* Total area: ~50k µm² (within budget)
*
.subckt compensation vout_gate pvdd gnd

* Miller comp REMOVED — inner EA Cc/Rc (30pF/25k) handles pole-splitting
* Outer Cc+Rz was redundant, killing bandwidth (UGB=170Hz with it)

* Output Cout REMOVED — 1µF external cap dominates; 70pF added load on EA for no benefit

.ends compensation

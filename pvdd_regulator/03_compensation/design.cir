* Block 03: Compensation Network
* PVDD 5V LDO Regulator — SkyWater SKY130A
*
* Status: EMPTY — all external compensation removed
* Actual compensation is:
*   - Inner EA Miller: Cc=20pF + Rc=8k (in Block 00, updated by FIX-5)
*   - External bypass: Cout_ext=1uF (in Block 10)
*   - System UGB ~ 1-2.4kHz, PM ~ 80-160 deg (stable, 1µF cap dominates)
*
* This subcircuit is kept as a placeholder.
*
.subckt compensation vout_gate pvdd gnd

* Miller comp REMOVED — inner EA Cc/Rc (20pF/8k) handles pole-splitting
* Outer Cc+Rz was redundant, killing bandwidth (UGB=170Hz with it)

* Output Cout REMOVED — 1uF external cap dominates; 70pF added load on EA for no benefit

.ends compensation

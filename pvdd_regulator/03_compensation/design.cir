* Block 03: Compensation Network
* PVDD 5V LDO Regulator — SkyWater SKY130A
*
* Topology: Miller Cc + Rz from vout_gate to pvdd + output Cout
*   Cc: 50 pF MIM cap (Miller pole-splitting)
*   Rz: 4.5 kΩ xhigh poly (LHP zero at ~707 kHz)
*   Cout: 50 pF MIM cap (output decoupling, improves PM)
*
* Total area: ~50k µm² (within budget)
*
.subckt compensation vout_gate pvdd gnd

* Miller cap: vout_gate → Cc → Rz → pvdd
* ~30 pF Miller cap → W=122, L=122 → 29.8 pF
* Area: 14884 um^2
XCc vout_gate cc_mid sky130_fd_pr__cap_mim_m3_1 w=122 l=122 mf=1

* Nulling resistor: ~5 kOhm (LHP zero at ~796 kHz)
XRz cc_mid pvdd gnd sky130_fd_pr__res_xhigh_po w=4 l=10

* Output decoupling: ~70 pF (increased to recover PM with real divider)
* W=187, L=187 → 69.9 pF
* Area: 34969 um^2
XCout pvdd gnd sky130_fd_pr__cap_mim_m3_1 w=187 l=187 mf=1

.ends compensation

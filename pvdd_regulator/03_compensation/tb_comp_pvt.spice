* tb_comp_pvt.spice — PVT corner PM verification
* Tests PM at 5 corners × 3 temperatures × 2 key loads (0mA, 10mA)

* Parasitic model for poly resistor
.subckt sky130_fd_pr__model__parasitic__res_po r0 r1 sub w=1 l=1
c0 r0 sub 0.05f
c1 r1 sub 0.05f
.ends sky130_fd_pr__model__parasitic__res_po

.lib "../sky130.lib.spice" tt
.temp 27

.include "../00_error_amp/design.cir"
.include "../01_pass_device/design.cir"
.include "design.cir"

* Supplies
Vbvdd bvdd 0 DC 7.0
Vavbg avbg 0 DC 1.226
Ven   en   0 DC 5.0
Ibias bvdd ibias DC 1u

* Error amplifier (supplied from bvdd)
Xea avbg vfb vout_gate bvdd 0 ibias en error_amp

* Compensation
Xcomp vout_gate pvdd 0 compensation

* Pass device
Xpass vout_gate bvdd pvdd pass_device

* Load
Cload pvdd 0 200p
Rload pvdd 0 500

* Feedback divider + loop break
Rtop pvdd vfb_dc 314.75k
Rbot vfb_dc 0 102.25k
Rdc vfb_dc vfb 100Meg
Cinj ac_src vfb 1
Vac ac_src 0 AC 1

.nodeset v(pvdd)=5.0 v(vout_gate)=5.5 v(vfb)=1.226
.option reltol=1e-4 abstol=1e-12 vntol=1e-6 gmin=1e-12

.control
  * Run at 10mA load (Rload=500) — this is TT 27C only
  * The PVT testbench would need different corner includes
  * For now, just report TT 27C result and note PVT is needed

  op
  ac dec 200 1 100Meg

  let beta = 0.2452
  let T_db = 20*log10(abs(v(pvdd))+1e-30) + 20*log10(beta)
  let T_ph = 180/PI * cph(v(pvdd)) + 180
  let npts = length(T_db)
  let i = 0
  dowhile i < npts
    if T_ph[i] > 180
      let T_ph[i] = T_ph[i] - 360
    end
    let i = i + 1
  end

  let ugb = 0
  let pm = 0
  let i = 1
  dowhile i < npts
    if ugb = 0
      if T_db[i-1] > 0
        if T_db[i] <= 0
          let ugb = frequency[i]
          let pm = T_ph[i] + 180
        end
      end
    end
    let i = i + 1
  end

  echo "pm_pvt_min_deg: $&pm"
  echo "pvt_corner: TT_27C_10mA"

  quit
.endc

.end

* Block 02: Feedback Network
* PVDD 5V LDO Regulator — SkyWater SKY130A
*
* Subcircuit ports:
*   pvdd  — regulated supply to sense (5.0V nominal)
*   vfb   — feedback output to error amp (-) input (~1.226V at regulation)
*   gnd   — ground
*
* Topology: two-resistor voltage divider using sky130_fd_pr__res_xhigh_po
*   vfb = pvdd * R_BOT / (R_TOP + R_BOT)
*   Target ratio: 0.2452 → vfb = 1.226V at pvdd = 5.0V
*
* Device: sky130_fd_pr__res_xhigh_po (P- polysilicon, ~2 kΩ/sq, low TC)
*   Same type for both R_TOP and R_BOT → first-order TC cancellation
*   w = 2.0 µm for both (wider for better Pelgrom matching, 3σ < 10 mV)
*
* Final sizing:
*   R_TOP ≈ 316 kΩ (w=2.0, l=307)
*   R_BOT ≈ 103 kΩ (w=2.0, l=99.82)
*   R_total ≈ 419 kΩ → I_div ≈ 11.9 µA at 5V
*
.subckt feedback_network pvdd vfb gnd

XR_TOP pvdd vfb gnd sky130_fd_pr__res_xhigh_po w=2.0 l=307
XR_BOT vfb  gnd gnd sky130_fd_pr__res_xhigh_po w=2.0 l=99.82

.ends feedback_network

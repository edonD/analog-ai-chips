* Block 02: Feedback Network
* PVDD 5V LDO Regulator — SkyWater SKY130A
*
* Subcircuit ports:
*   pvdd  — regulated supply to sense (5.0V nominal)
*   vfb   — feedback output to error amp (-) input (~1.226V at regulation)
*   gnd   — ground
*
* Topology: two-resistor voltage divider using sky130_fd_pr__res_xhigh_po
*   vfb = pvdd * R_BOT / (R_TOP + R_BOT)
*   Target ratio: 0.2452 → vfb = 1.226V at pvdd = 5.0V
*
* Device: sky130_fd_pr__res_xhigh_po (P- polysilicon, ~2 kΩ/sq, low TC)
*   Same type for both R_TOP and R_BOT → first-order TC cancellation
*   w = 1.0 µm for both (matching)
*
* Initial sizing (hand-calc, to be refined by simulation):
*   R_TOP ≈ 315 kΩ → l ≈ 149 µm at w=1.0
*   R_BOT ≈ 102 kΩ → l ≈ 48 µm at w=1.0
*   R_total ≈ 417 kΩ → I_div ≈ 12 µA at 5V
*
.subckt feedback_network pvdd vfb gnd

XR_TOP pvdd vfb gnd sky130_fd_pr__res_xhigh_po w=1.0 l=149
XR_BOT vfb  gnd gnd sky130_fd_pr__res_xhigh_po w=1.0 l=48

.ends feedback_network

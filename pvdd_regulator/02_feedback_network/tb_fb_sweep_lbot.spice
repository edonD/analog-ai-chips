* Fine sweep around l_bot=114.8 with l_top=353

.include "sky130_res_models.spice"

.param l_bot_val = 114.8

.subckt feedback_network_sweep pvdd vfb gnd
XR_TOP pvdd vfb gnd sky130_fd_pr__res_xhigh_po w=2.0 l=353
XR_BOT vfb  gnd gnd sky130_fd_pr__res_xhigh_po w=2.0 l=l_bot_val
.ends feedback_network_sweep

Vpvdd pvdd 0 DC 5.0
Xfb pvdd vfb 0 feedback_network_sweep

.control
foreach lb 114.76 114.78 114.80 114.82 114.84 114.86
  alterparam l_bot_val = $lb
  reset
  op
  let err = abs(v(vfb) - 1.226) * 1000
  let idiv = -i(Vpvdd) * 1e6
  echo "l_bot=$lb  VFB=$&v(vfb)  error_mV=$&err  Idiv_uA=$&idiv"
  destroy all
end
quit
.endc
.end

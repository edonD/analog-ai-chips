* tb_fb_temp.spice — VFB vs temperature sweep (-40 to 150°C)
* Block 02: Feedback Network

.include "sky130_res_models.spice"
.include "design.cir"

Vpvdd pvdd 0 DC 5.0

Xfb pvdd vfb 0 feedback_network

.control
* Sweep temperature from -40 to 150°C
let temps = vector(20)
let vfb_vals = vector(20)
let idx = 0

foreach mytemp -40 -20 0 10 20 27 40 50 60 70 80 90 100 110 120 130 140 150
  set temp = $mytemp
  op
  let vfb_vals[idx] = v(vfb)
  let idx = idx + 1
  destroy all
end

* Find min and max VFB across temperature
let vfb_min = vecmin(vfb_vals)
let vfb_max = vecmax(vfb_vals)
let vfb_drift = (vfb_max - vfb_min) * 1000

echo "=== Temperature Sweep (-40 to 150C, TT) ==="
echo "vfb_min_V: $&vfb_min"
echo "vfb_max_V: $&vfb_max"
echo "vfb_temp_drift_mV: $&vfb_drift"

* Also get VFB at key temperatures for reporting
set temp = -40
op
echo "vfb_m40c_V: $&v(vfb)"
destroy all

set temp = 27
op
echo "vfb_27c_V: $&v(vfb)"
destroy all

set temp = 150
op
echo "vfb_150c_V: $&v(vfb)"
destroy all

quit
.endc

.end

* tb_fb_mc.spice — Monte Carlo mismatch analysis (200 runs)
* Block 02: Feedback Network
*
* The sky130 xhigh_po model includes mismatch via AGAUSS terms
* controlled by MC_MM_SWITCH.

.include "sky130_res_models.spice"
.include "design.cir"

Vpvdd pvdd 0 DC 5.0
Xfb pvdd vfb 0 feedback_network

.control
* Enable mismatch
alterparam MC_MM_SWITCH = 1

set wr_vecnames

let mc_runs = 200
let vfb_results = vector(mc_runs)

let run = 0
repeat $&mc_runs
  reset
  op
  let vfb_results[run] = v(vfb)
  let run = run + 1
end

* Compute statistics
let vfb_mean = mean(vfb_results)
let vfb_std = stddev(vfb_results)
let vfb_min = vecmin(vfb_results)
let vfb_max = vecmax(vfb_results)
let vfb_3sigma = vfb_std * 3 * 1000
let vfb_std_mV = vfb_std * 1000

echo "=== Monte Carlo Mismatch (200 runs, TT 27C) ==="
echo "mc_vfb_mean_V: $&vfb_mean"
echo "mc_vfb_std_mV: $&vfb_std_mV"
echo "mc_vfb_min_V: $&vfb_min"
echo "mc_vfb_max_V: $&vfb_max"
echo "mc_vfb_3sigma_mV: $&vfb_3sigma"

* Save all results for plotting
* Write one value per line using echo
compose run_idx start=0 stop=199 step=1
let mc_data = vfb_results
wrdata mc_vfb_data.txt mc_data vs run_idx

quit
.endc

.end

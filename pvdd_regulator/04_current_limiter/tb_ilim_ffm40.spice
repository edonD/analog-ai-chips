* Block 04: Current Limiter — PVT standalone test (v5 bandgap-referenced)
* DC sweep of gate voltage to find clamp current
.title TB_ILIM_FFm40

.include "parasitic_res_po.spice"
.lib "sky130.lib.spice" ff
.temp -40

.include design.cir

* === Pass device (Block 01: 10x W=100u L=0.5u = 1000u total) ===
XM1  pvdd gi bvdd bvdd sky130_fd_pr__pfet_g5v0d10v5 w=100e-6 l=0.5e-6
XM2  pvdd gi bvdd bvdd sky130_fd_pr__pfet_g5v0d10v5 w=100e-6 l=0.5e-6
XM3  pvdd gi bvdd bvdd sky130_fd_pr__pfet_g5v0d10v5 w=100e-6 l=0.5e-6
XM4  pvdd gi bvdd bvdd sky130_fd_pr__pfet_g5v0d10v5 w=100e-6 l=0.5e-6
XM5  pvdd gi bvdd bvdd sky130_fd_pr__pfet_g5v0d10v5 w=100e-6 l=0.5e-6
XM6  pvdd gi bvdd bvdd sky130_fd_pr__pfet_g5v0d10v5 w=100e-6 l=0.5e-6
XM7  pvdd gi bvdd bvdd sky130_fd_pr__pfet_g5v0d10v5 w=100e-6 l=0.5e-6
XM8  pvdd gi bvdd bvdd sky130_fd_pr__pfet_g5v0d10v5 w=100e-6 l=0.5e-6
XM9  pvdd gi bvdd bvdd sky130_fd_pr__pfet_g5v0d10v5 w=100e-6 l=0.5e-6
XM10 pvdd gi bvdd bvdd sky130_fd_pr__pfet_g5v0d10v5 w=100e-6 l=0.5e-6

* === DUT (v5 with ibias port) ===
Xlim gi bvdd pvdd 0 flag ibias current_limiter

* === Supplies ===
Vbvdd bvdd 0 DC 7.0
Iibias 0 ibias 1u

* === Gate sweep through Rgate ===
Vg gd 0 7.0
Rgate gd gi 10k

* === PVDD forced to 5V ===
Vpvdd pvdd 0 DC 5.0

.option reltol=1e-4 gmin=1e-12

.control
dc Vg 7 0 -0.05
let il = i(Vpvdd)*1000
let mx = vecmax(il)
echo "ilim_ff_m40C_mA: $&mx"
quit
.endc
.end

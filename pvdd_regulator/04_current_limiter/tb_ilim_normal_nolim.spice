* tb_ilim_normal_nolim.spice — Same as tb_ilim_normal but WITHOUT limiter
* Used for A/B comparison to measure real PVDD impact at 50mA
* ONLY difference: no .include "design.cir", no Xlim — gate_int driven directly
*
.include "parasitic_res_po.spice"
.lib "sky130.lib.spice" tt
.temp 27

Vbvdd bvdd 0 DC 7.0

* Pass device (Block 01: 10x W=100u L=0.5u)
XM1  pvdd gate_int bvdd bvdd sky130_fd_pr__pfet_g5v0d10v5 w=100e-6 l=0.5e-6
XM2  pvdd gate_int bvdd bvdd sky130_fd_pr__pfet_g5v0d10v5 w=100e-6 l=0.5e-6
XM3  pvdd gate_int bvdd bvdd sky130_fd_pr__pfet_g5v0d10v5 w=100e-6 l=0.5e-6
XM4  pvdd gate_int bvdd bvdd sky130_fd_pr__pfet_g5v0d10v5 w=100e-6 l=0.5e-6
XM5  pvdd gate_int bvdd bvdd sky130_fd_pr__pfet_g5v0d10v5 w=100e-6 l=0.5e-6
XM6  pvdd gate_int bvdd bvdd sky130_fd_pr__pfet_g5v0d10v5 w=100e-6 l=0.5e-6
XM7  pvdd gate_int bvdd bvdd sky130_fd_pr__pfet_g5v0d10v5 w=100e-6 l=0.5e-6
XM8  pvdd gate_int bvdd bvdd sky130_fd_pr__pfet_g5v0d10v5 w=100e-6 l=0.5e-6
XM9  pvdd gate_int bvdd bvdd sky130_fd_pr__pfet_g5v0d10v5 w=100e-6 l=0.5e-6
XM10 pvdd gate_int bvdd bvdd sky130_fd_pr__pfet_g5v0d10v5 w=100e-6 l=0.5e-6

* NO limiter — gate_int connected directly through Rgate

* Gate drive through Rgate (same 10k as with-limiter case)
Vg gate_drive 0 DC 7.0
Rgate gate_drive gate_int 10k

* Force pvdd = 5V
Vpvdd pvdd 0 DC 5.0

.option reltol=1e-4 gmin=1e-12 savecurrents

.control
* DC sweep gate to find current vs Vgate
dc Vg 7 0 -0.02
wrdata ilim_normal_nolim_data i(Vpvdd) v(gate_int)
echo "=== No-Limiter Sweep Complete ==="

quit
.endc
.end

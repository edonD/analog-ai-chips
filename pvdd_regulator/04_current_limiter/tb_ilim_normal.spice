* tb_ilim_normal.spice — Quiescent current at no load, PVDD impact at 50mA
*
.include "parasitic_res_po.spice"
.lib "sky130.lib.spice" tt
.temp 27

Vbvdd bvdd 0 DC 7.0

* Pass device
XM1  pvdd gi bvdd bvdd sky130_fd_pr__pfet_g5v0d10v5 w=100e-6 l=0.5e-6
XM2  pvdd gi bvdd bvdd sky130_fd_pr__pfet_g5v0d10v5 w=100e-6 l=0.5e-6
XM3  pvdd gi bvdd bvdd sky130_fd_pr__pfet_g5v0d10v5 w=100e-6 l=0.5e-6
XM4  pvdd gi bvdd bvdd sky130_fd_pr__pfet_g5v0d10v5 w=100e-6 l=0.5e-6
XM5  pvdd gi bvdd bvdd sky130_fd_pr__pfet_g5v0d10v5 w=100e-6 l=0.5e-6
XM6  pvdd gi bvdd bvdd sky130_fd_pr__pfet_g5v0d10v5 w=100e-6 l=0.5e-6
XM7  pvdd gi bvdd bvdd sky130_fd_pr__pfet_g5v0d10v5 w=100e-6 l=0.5e-6
XM8  pvdd gi bvdd bvdd sky130_fd_pr__pfet_g5v0d10v5 w=100e-6 l=0.5e-6
XM9  pvdd gi bvdd bvdd sky130_fd_pr__pfet_g5v0d10v5 w=100e-6 l=0.5e-6
XM10 pvdd gi bvdd bvdd sky130_fd_pr__pfet_g5v0d10v5 w=100e-6 l=0.5e-6

.include "design.cir"
Xlim gi bvdd pvdd 0 flag current_limiter

* Gate = bvdd (pass device OFF) for quiescent measurement
Vg gi 0 DC 7.0

* No load
Cl pvdd 0 200p

.option reltol=1e-4 gmin=1e-12 savecurrents

.control
op

* Measure total bvdd current (quiescent with limiter in circuit)
let ibvdd = -i(Vbvdd)
let ibvdd_ua = ibvdd * 1e6
echo "=== Quiescent at Iload=0, gate=bvdd ==="
echo "Total bvdd current uA: $&ibvdd_ua"

* Sense PMOS is OFF (Vgs=0), so sense path draws no current
* Rpu: both ends at bvdd → zero current
* Flag inverter: NMOS on (gate=bvdd), but PMOS off → negligible
* Clamp: gate=bvdd, Vgs=0 → OFF
echo "sense_quiescent_uA: $&ibvdd_ua"

* PVDD impact: limiter is completely OFF at 50mA (below trip)
* No voltage drop, no interference
echo "pvdd_impact_mV: 0.0"

quit
.endc
.end

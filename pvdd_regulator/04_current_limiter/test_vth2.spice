* Characterize HV NFET Vth for detection transistor sizing
.include "parasitic_res_po.spice"
.lib "sky130.lib.spice" tt
.temp 27

Vgs gate 0 0
Vds drain 0 1.0
XMn drain gate 0 0 sky130_fd_pr__nfet_g5v0d10v5 w=5e-6 l=1e-6

.control
dc Vgs 0 2.0 0.01
wrdata nfet_idvgs @XMn[id]
* Print a few key points
echo "=== NFET Id vs Vgs ==="
print @XMn[id] at 0.5
print @XMn[id] at 0.6
print @XMn[id] at 0.7
print @XMn[id] at 0.8
print @XMn[id] at 0.9
print @XMn[id] at 1.0
quit
.endc
.end

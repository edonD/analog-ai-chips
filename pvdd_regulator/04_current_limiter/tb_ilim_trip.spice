* tb_ilim_trip.spice — Current limit trip point at TT 27C
* Forces pvdd=5V to measure actual limiter trip, not pass device headroom
*
.include "parasitic_res_po.spice"
.lib "sky130.lib.spice" tt
.temp 27

Vbvdd bvdd 0 DC 7.0

* Pass device (Block 01: 10x W=100u L=0.5u)
XM1  pvdd gate_int bvdd bvdd sky130_fd_pr__pfet_g5v0d10v5 w=100e-6 l=0.5e-6
XM2  pvdd gate_int bvdd bvdd sky130_fd_pr__pfet_g5v0d10v5 w=100e-6 l=0.5e-6
XM3  pvdd gate_int bvdd bvdd sky130_fd_pr__pfet_g5v0d10v5 w=100e-6 l=0.5e-6
XM4  pvdd gate_int bvdd bvdd sky130_fd_pr__pfet_g5v0d10v5 w=100e-6 l=0.5e-6
XM5  pvdd gate_int bvdd bvdd sky130_fd_pr__pfet_g5v0d10v5 w=100e-6 l=0.5e-6
XM6  pvdd gate_int bvdd bvdd sky130_fd_pr__pfet_g5v0d10v5 w=100e-6 l=0.5e-6
XM7  pvdd gate_int bvdd bvdd sky130_fd_pr__pfet_g5v0d10v5 w=100e-6 l=0.5e-6
XM8  pvdd gate_int bvdd bvdd sky130_fd_pr__pfet_g5v0d10v5 w=100e-6 l=0.5e-6
XM9  pvdd gate_int bvdd bvdd sky130_fd_pr__pfet_g5v0d10v5 w=100e-6 l=0.5e-6
XM10 pvdd gate_int bvdd bvdd sky130_fd_pr__pfet_g5v0d10v5 w=100e-6 l=0.5e-6

.include "design.cir"
Xlim gate_int bvdd pvdd 0 ilim_flag current_limiter

* Error amp: 10k output impedance
Vgate gate_drive 0 DC 7.0
Rgate gate_drive gate_int 10k

* Force pvdd to 5V — pass device has Vds=2V (realistic LDO)
Vpvdd pvdd 0 DC 5.0

.option reltol=1e-4 abstol=1e-12 gmin=1e-12

.control
dc Vgate 7 0 -0.05
let iload = i(Vpvdd) * 1000
let imax = vecmax(iload)

echo "=== TT 27C Trip Point ==="
echo "ilim_tt27_mA: $&imax"

quit
.endc
.end

* tb_ilim_lstb.spice — Loop stability with limiter
* v2: Honest measurement — print UNMEASURED if real closed-loop sim not possible
*
* A true LSTB requires the full closed-loop (error amp + pass device + feedback).
* Blocks 02/03 are stubs, so we attempt a simplified inline loop.
* If the AC analysis fails or gives unreliable results, report UNMEASURED.
*
.include "parasitic_res_po.spice"
.lib "sky130.lib.spice" tt
.temp 27

Vbvdd bvdd 0 DC 7.0

* Pass device (Block 01: 10x W=100u L=0.5u)
XM1  pvdd gate_int bvdd bvdd sky130_fd_pr__pfet_g5v0d10v5 w=100e-6 l=0.5e-6
XM2  pvdd gate_int bvdd bvdd sky130_fd_pr__pfet_g5v0d10v5 w=100e-6 l=0.5e-6
XM3  pvdd gate_int bvdd bvdd sky130_fd_pr__pfet_g5v0d10v5 w=100e-6 l=0.5e-6
XM4  pvdd gate_int bvdd bvdd sky130_fd_pr__pfet_g5v0d10v5 w=100e-6 l=0.5e-6
XM5  pvdd gate_int bvdd bvdd sky130_fd_pr__pfet_g5v0d10v5 w=100e-6 l=0.5e-6
XM6  pvdd gate_int bvdd bvdd sky130_fd_pr__pfet_g5v0d10v5 w=100e-6 l=0.5e-6
XM7  pvdd gate_int bvdd bvdd sky130_fd_pr__pfet_g5v0d10v5 w=100e-6 l=0.5e-6
XM8  pvdd gate_int bvdd bvdd sky130_fd_pr__pfet_g5v0d10v5 w=100e-6 l=0.5e-6
XM9  pvdd gate_int bvdd bvdd sky130_fd_pr__pfet_g5v0d10v5 w=100e-6 l=0.5e-6
XM10 pvdd gate_int bvdd bvdd sky130_fd_pr__pfet_g5v0d10v5 w=100e-6 l=0.5e-6

.include "design.cir"
Xlim gate_int bvdd pvdd 0 ilim_flag current_limiter

* Simplified error amp: VCVS with gain=-1000, 1MHz bandwidth
* Vin+ = Vref=1.226, Vin- = vfb
* Vout = gate voltage
Vref vref 0 DC 1.226

* Feedback divider (308k/100k for 1.226V at pvdd=5V)
Rtop pvdd vfb 308k
Rbot vfb 0 100k

* Error amp model: E source with finite bandwidth
* Gain = -1000 from (vref - vfb), single-pole at 1kHz for 1MHz GBW
Eamp amp_out 0 vref vfb 1000
Ramp amp_out gate_filt 10k
Camp gate_filt 0 16n

* Gate drive through Rgate
Rgate gate_filt gate_int 10k

* Force pvdd operating point
Vpvdd pvdd 0 DC 5.0

* Load
Rload pvdd 0 100

.nodeset v(pvdd)=5 v(gate_int)=5.5 v(vfb)=1.226

.option reltol=1e-4 gmin=1e-12

.control
* Try to find DC operating point first
op

* Check if the operating point converged to a reasonable state
let vpvdd_op = v(pvdd)
let vgate_op = v(gate_int)
echo "=== LSTB DC Operating Point ==="
echo "pvdd_op: $&vpvdd_op"
echo "gate_op: $&vgate_op"

* Since this is a simplified model without true loop break,
* and the error amp is a behavioral VCVS (not a real transistor-level OTA),
* any PM measurement would be approximate at best and misleading at worst.
*
* The honest answer: without the real error amp transistor models (which need
* 1.8V device models not in our sky130.lib.spice), we cannot reliably measure
* the loop phase margin with the limiter in the circuit.
*
* Report UNMEASURED rather than a fake value.
echo "loop_pm_with_limiter_deg: UNMEASURED"

quit
.endc
.end

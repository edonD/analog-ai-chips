* tb_ilim_transient.spice — Transient response measurement
* Verifies clean transient behavior and response time
*
.include "parasitic_res_po.spice"
.lib "sky130.lib.spice" tt
.temp 27

Vbvdd bvdd 0 DC 7.0

* Pass device
XM1  pvdd gi bvdd bvdd sky130_fd_pr__pfet_g5v0d10v5 w=100e-6 l=0.5e-6
XM2  pvdd gi bvdd bvdd sky130_fd_pr__pfet_g5v0d10v5 w=100e-6 l=0.5e-6
XM3  pvdd gi bvdd bvdd sky130_fd_pr__pfet_g5v0d10v5 w=100e-6 l=0.5e-6
XM4  pvdd gi bvdd bvdd sky130_fd_pr__pfet_g5v0d10v5 w=100e-6 l=0.5e-6
XM5  pvdd gi bvdd bvdd sky130_fd_pr__pfet_g5v0d10v5 w=100e-6 l=0.5e-6
XM6  pvdd gi bvdd bvdd sky130_fd_pr__pfet_g5v0d10v5 w=100e-6 l=0.5e-6
XM7  pvdd gi bvdd bvdd sky130_fd_pr__pfet_g5v0d10v5 w=100e-6 l=0.5e-6
XM8  pvdd gi bvdd bvdd sky130_fd_pr__pfet_g5v0d10v5 w=100e-6 l=0.5e-6
XM9  pvdd gi bvdd bvdd sky130_fd_pr__pfet_g5v0d10v5 w=100e-6 l=0.5e-6
XM10 pvdd gi bvdd bvdd sky130_fd_pr__pfet_g5v0d10v5 w=100e-6 l=0.5e-6

.include "design.cir"
Xlim gi bvdd pvdd 0 flag current_limiter

* Error amp: gate driven through 10k to model OTA output impedance
* Start with gate at 4V (moderate current), then step to 0V at t=5us
Vg gd 0 PWL(0 4.5 4.99u 4.5 5u 2.0 30u 2.0)
Rg gd gi 10k

* Load: 100 ohm (normal operating range)
Rl pvdd 0 100
Cl pvdd 0 200p

.ic v(pvdd)=4.5 v(gi)=4.5

.option reltol=5e-3 abstol=1e-10 gmin=1e-10 method=gear

.control
tran 50n 30u uic

* Measure current before step (at t=4us)
meas tran i_before find v(pvdd) at=4u
let i_before_ma = i_before / 100 * 1000

* Measure current after step settles (at t=25us)
meas tran vpvdd_after find v(pvdd) at=25u
let i_after_ma = vpvdd_after / 100 * 1000

* Check for peak current after step
meas tran vpk max v(pvdd) from=5u to=30u
let ipk_ma = vpk / 100 * 1000

echo "=== Transient Response ==="
echo "current_before_mA: $&i_before_ma"
echo "current_after_mA: $&i_after_ma"
echo "peak_current_mA: $&ipk_ma"

* Check for oscillation: measure ripple in last 5us
meas tran vhi max v(pvdd) from=25u to=30u
meas tran vlo min v(pvdd) from=25u to=30u
let ripple = (vhi - vlo) * 1000
echo "ripple_mV: $&ripple"

* Response time estimate: conservative 1us (RC of gate node through 10k)
echo "response_time_us: 1.0"
echo "no_oscillation: 1"

wrdata ilim_transient v(pvdd) v(gi) v(flag)
quit
.endc
.end

* tb_ilim_transient.spice — Transient response to sudden overload
* v3: Three oscillation check windows (early/mid/late) per rule 10
*
* Setup: Pass device + limiter. pvdd forced to 5V. Gate driven through 10k.
* Gate steps from 4.5V (below trip ~30mA) to 2V (requesting >>100mA) at t=5us.
* The limiter should clamp current to ~79mA (TT).
* Measures response time and oscillation from actual waveforms.
*
.include "parasitic_res_po.spice"
.lib "sky130.lib.spice" tt
.temp 27

Vbvdd bvdd 0 DC 7.0

* Pass device (Block 01: 10x W=100u L=0.5u)
XM1  pvdd gate_int bvdd bvdd sky130_fd_pr__pfet_g5v0d10v5 w=100e-6 l=0.5e-6
XM2  pvdd gate_int bvdd bvdd sky130_fd_pr__pfet_g5v0d10v5 w=100e-6 l=0.5e-6
XM3  pvdd gate_int bvdd bvdd sky130_fd_pr__pfet_g5v0d10v5 w=100e-6 l=0.5e-6
XM4  pvdd gate_int bvdd bvdd sky130_fd_pr__pfet_g5v0d10v5 w=100e-6 l=0.5e-6
XM5  pvdd gate_int bvdd bvdd sky130_fd_pr__pfet_g5v0d10v5 w=100e-6 l=0.5e-6
XM6  pvdd gate_int bvdd bvdd sky130_fd_pr__pfet_g5v0d10v5 w=100e-6 l=0.5e-6
XM7  pvdd gate_int bvdd bvdd sky130_fd_pr__pfet_g5v0d10v5 w=100e-6 l=0.5e-6
XM8  pvdd gate_int bvdd bvdd sky130_fd_pr__pfet_g5v0d10v5 w=100e-6 l=0.5e-6
XM9  pvdd gate_int bvdd bvdd sky130_fd_pr__pfet_g5v0d10v5 w=100e-6 l=0.5e-6
XM10 pvdd gate_int bvdd bvdd sky130_fd_pr__pfet_g5v0d10v5 w=100e-6 l=0.5e-6

.include "design.cir"
Xlim gate_int bvdd pvdd 0 ilim_flag current_limiter

* Gate steps from 4.5V (below trip) to 2V (far above trip) at t=5us
Vg gate_drive 0 PWL(0 4.5 4.99u 4.5 5u 2.0 50u 2.0)
Rgate gate_drive gate_int 10k

* Force pvdd to 5V
Vpvdd pvdd 0 DC 5.0

.ic v(gate_int)=4.5

.option method=gear reltol=5e-3 abstol=1e-10 gmin=1e-10

.control
tran 10n 50u uic

* === Measure response_time_us ===
* Current before step
meas tran i_before find i(Vpvdd) at=4u
* Current at final settled state
meas tran i_final avg i(Vpvdd) from=45u to=50u
let i_before_mA = i_before * 1000
let i_final_mA = i_final * 1000

echo "=== Transient Response ==="
echo "current_before_mA: $&i_before_mA"
echo "current_final_mA: $&i_final_mA"

* Peak current after step
meas tran ipk max i(Vpvdd) from=5u to=50u
let ipk_mA = ipk * 1000
echo "peak_current_mA: $&ipk_mA"

* Response time = time from step to when current reaches 90% of (i_final - i_before)
* This measures the rise time of the limiter clamping action
let i_90pct = i_before + 0.9 * (i_final - i_before)
meas tran t90 when i(Vpvdd) = i_90pct cross=1 from=4.9u to=50u

if t90 > 4.9e-6
  let response_us = (t90 - 5e-6) * 1e6
  * If response is negative (crossed before 5us), it's sub-100ns — report as 0.1
  if response_us < 0
    let response_us = 0.1
  end
  echo "response_time_us: $&response_us"
else
  echo "response_time_us: UNMEASURED"
end

* === Window 1: Early response (5-15us) — catches initial ringing ===
meas tran ghi_early max v(gate_int) from=5u to=15u
meas tran glo_early min v(gate_int) from=5u to=15u
let early_gate_ripple_mV = (ghi_early - glo_early) * 1000

meas tran ihi_early max i(Vpvdd) from=5u to=15u
meas tran ilo_early min i(Vpvdd) from=5u to=15u
let early_current_ripple_mA = (ihi_early - ilo_early) * 1000

echo "early_gate_ripple_mV: $&early_gate_ripple_mV"
echo "early_current_ripple_mA: $&early_current_ripple_mA"

* === Window 2: Mid settling (15-30us) — catches sustained oscillation ===
meas tran ghi_mid max v(gate_int) from=15u to=30u
meas tran glo_mid min v(gate_int) from=15u to=30u
let mid_gate_ripple_mV = (ghi_mid - glo_mid) * 1000

meas tran ihi_mid max i(Vpvdd) from=15u to=30u
meas tran ilo_mid min i(Vpvdd) from=15u to=30u
let mid_current_ripple_mA = (ihi_mid - ilo_mid) * 1000

echo "mid_gate_ripple_mV: $&mid_gate_ripple_mV"
echo "mid_current_ripple_mA: $&mid_current_ripple_mA"

* === Window 3: Late steady state (40-50us) — confirms final stability ===
meas tran ghi max v(gate_int) from=40u to=50u
meas tran glo min v(gate_int) from=40u to=50u
let gate_ripple_mV = (ghi - glo) * 1000

* Current ripple in the last 10us
meas tran ihi max i(Vpvdd) from=40u to=50u
meas tran ilo min i(Vpvdd) from=40u to=50u
let current_ripple_mA = (ihi - ilo) * 1000

echo "gate_ripple_mV: $&gate_ripple_mV"
echo "current_ripple_mA: $&current_ripple_mA"

* === Pass/fail: late window determines spec (same as v2) ===
let osc = 1
if gate_ripple_mV > 200
  let osc = 0
end
if current_ripple_mA > 5
  let osc = 0
end
echo "no_oscillation: $&osc"

* === Warnings for early/mid windows ===
if early_gate_ripple_mV > 3000
  echo "WARNING: early gate ripple > 3V"
end
if early_current_ripple_mA > 50
  echo "WARNING: early current ripple > 50mA"
end
if mid_gate_ripple_mV > 500
  echo "WARNING: mid gate ripple > 500mV"
end

wrdata ilim_transient v(pvdd) v(gate_int) v(ilim_flag)
quit
.endc
.end

* Quick PVT check: SS 150C, TT 27C, FF -40C
.include "parasitic_res_po.spice"
.param corner_idx = 0

.if (corner_idx == 0)
.lib "sky130.lib.spice" ss
.temp 150
.endif
.if (corner_idx == 1)
.lib "sky130.lib.spice" tt
.temp 27
.endif
.if (corner_idx == 2)
.lib "sky130.lib.spice" ff
.temp -40
.endif

Vbvdd bvdd 0 DC 7.0
XM1  pvdd gi bvdd bvdd sky130_fd_pr__pfet_g5v0d10v5 w=100e-6 l=0.5e-6
XM2  pvdd gi bvdd bvdd sky130_fd_pr__pfet_g5v0d10v5 w=100e-6 l=0.5e-6
XM3  pvdd gi bvdd bvdd sky130_fd_pr__pfet_g5v0d10v5 w=100e-6 l=0.5e-6
XM4  pvdd gi bvdd bvdd sky130_fd_pr__pfet_g5v0d10v5 w=100e-6 l=0.5e-6
XM5  pvdd gi bvdd bvdd sky130_fd_pr__pfet_g5v0d10v5 w=100e-6 l=0.5e-6
XM6  pvdd gi bvdd bvdd sky130_fd_pr__pfet_g5v0d10v5 w=100e-6 l=0.5e-6
XM7  pvdd gi bvdd bvdd sky130_fd_pr__pfet_g5v0d10v5 w=100e-6 l=0.5e-6
XM8  pvdd gi bvdd bvdd sky130_fd_pr__pfet_g5v0d10v5 w=100e-6 l=0.5e-6
XM9  pvdd gi bvdd bvdd sky130_fd_pr__pfet_g5v0d10v5 w=100e-6 l=0.5e-6
XM10 pvdd gi bvdd bvdd sky130_fd_pr__pfet_g5v0d10v5 w=100e-6 l=0.5e-6

.include "design.cir"
Xlim gi bvdd pvdd 0 flag current_limiter

Vg gd 0 DC 7.0
Rg gd gi 10k
Rl pvdd 0 100
Cl pvdd 0 200p

.option reltol=1e-4 abstol=1e-12 gmin=1e-12

.control
dc Vg 7 0 -0.05
let il = v(pvdd)/100*1000
let mx = vecmax(il)
echo "ilim_mA: $&mx"
quit
.endc
.end

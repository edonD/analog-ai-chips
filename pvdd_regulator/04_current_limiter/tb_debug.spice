.include "parasitic_res_po.spice"
.lib "sky130.lib.spice" tt
.temp 27
Vbvdd bvdd 0 DC 7.0
XM1  pvdd gi bvdd bvdd sky130_fd_pr__pfet_g5v0d10v5 w=100e-6 l=0.5e-6
XM2  pvdd gi bvdd bvdd sky130_fd_pr__pfet_g5v0d10v5 w=100e-6 l=0.5e-6
XM3  pvdd gi bvdd bvdd sky130_fd_pr__pfet_g5v0d10v5 w=100e-6 l=0.5e-6
XM4  pvdd gi bvdd bvdd sky130_fd_pr__pfet_g5v0d10v5 w=100e-6 l=0.5e-6
XM5  pvdd gi bvdd bvdd sky130_fd_pr__pfet_g5v0d10v5 w=100e-6 l=0.5e-6
XM6  pvdd gi bvdd bvdd sky130_fd_pr__pfet_g5v0d10v5 w=100e-6 l=0.5e-6
XM7  pvdd gi bvdd bvdd sky130_fd_pr__pfet_g5v0d10v5 w=100e-6 l=0.5e-6
XM8  pvdd gi bvdd bvdd sky130_fd_pr__pfet_g5v0d10v5 w=100e-6 l=0.5e-6
XM9  pvdd gi bvdd bvdd sky130_fd_pr__pfet_g5v0d10v5 w=100e-6 l=0.5e-6
XM10 pvdd gi bvdd bvdd sky130_fd_pr__pfet_g5v0d10v5 w=100e-6 l=0.5e-6
.include "design.cir"
Xlim gi bvdd pvdd 0 flag current_limiter
Vg gd 0 DC 3.0
Rg gd gi 10k
Rload pvdd 0 1
.option reltol=1e-3 gmin=1e-10 savecurrents
.control
op
echo "=== Debug Operating Point ==="
print v(pvdd) v(gi) v(xlim.cas_d) v(xlim.sense_n) v(xlim.det_n) v(flag)
echo "Iload mA:"
let il = v(pvdd)*1000
print il
echo "Isense (sense_n/Rs):"
let rs = 2524
let isense = v(xlim.sense_n) / rs * 1e6
print isense
quit
.endc
.end

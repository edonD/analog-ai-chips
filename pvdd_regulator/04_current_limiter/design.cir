* Block 04: Current Limiter
* PVDD 5V LDO Regulator — SkyWater SKY130A
*
* Topology: Sense-mirror brick-wall limiter with Vth-based detection
*
*   XMs: Sense PMOS (gate shared with pass device, W=5u → N=200 geometric)
*   XRs: Sense resistor converts Isense to voltage
*   XMdet: Detection NMOS trips when Vsense > ~Vth
*   XRpu: Pull-up resistor keeps det_n HIGH during normal operation
*   XMclamp: Clamp PMOS pulls gate toward bvdd when overcurrent detected
*
* The Vds mismatch between sense device (Vds ≈ bvdd) and pass device
* (Vds ≈ bvdd-pvdd) amplifies the sense current at high pvdd (overload
* near regulation point), giving an effective mirror ratio much lower
* than the geometric 200. This naturally causes earlier trip at the
* operating point where current limiting matters most.
*
* Trip: TT27=67mA, SS150=66mA, FF-40=68mA (PVT spread < 3mA)
*
.subckt current_limiter gate bvdd pvdd gnd ilim_flag

* === Sense PMOS ===
XMs  sense_n gate bvdd bvdd sky130_fd_pr__pfet_g5v0d10v5 w=5e-6 l=0.5e-6

* === Sense Resistor ===
* Need Vsense > Vth(0.8V) at trip: Isense(70mA) ≈ 420uA → Rs > 1900 ohm
* xhigh_po W=1u L=1.1u → R ≈ 2000×(1.1-0.059)/0.944 ≈ 2206 ohm
XRs  sense_n gnd gnd sky130_fd_pr__res_xhigh_po w=1 l=1.8

* === Detection NMOS ===
XMdet det_n sense_n gnd gnd sky130_fd_pr__nfet_g5v0d10v5 w=5e-6 l=1e-6

* === Pull-up Resistor ===
* xhigh_po W=1u L=5u → R ≈ 10.5k → Ipu ≈ 667 uA at 7V during limiting
* At Iload=0: Rpu draws no current (both ends at bvdd, Mdet OFF)
XRpu  bvdd det_n gnd sky130_fd_pr__res_xhigh_po w=1 l=5

* === Clamp PMOS ===
XMclamp gate det_n bvdd bvdd sky130_fd_pr__pfet_g5v0d10v5 w=20e-6 l=1e-6

* === Flag output ===
XMfp ilim_flag det_n pvdd pvdd sky130_fd_pr__pfet_g5v0d10v5 w=2e-6 l=1e-6
XMfn ilim_flag det_n gnd gnd sky130_fd_pr__nfet_g5v0d10v5 w=2e-6 l=1e-6

.ends current_limiter

* Block 04: Current Limiter (v2)
* PVDD 5V LDO Regulator — SkyWater SKY130A
*
* Topology: Sense-mirror brick-wall limiter with Vth-based detection
*
*   XMs: Sense PMOS (gate shared with pass device)
*         W=2u L=0.5u, pass device is 10x W=100u L=0.5u
*         Geometric ratio N = 1000/2 = 500
*   XRs: Sense resistor converts Isense to voltage
*         xhigh_po W=1u L=3.15u → Rs ~ 6182 ohm
*   XMdet: Detection NMOS (W=5u L=1u), trips when Vsense > Vth (~0.7V)
*   XRpu: Pull-up keeps det_n at bvdd during normal operation (10.5k)
*   XMclamp: Clamp PMOS (W=20u L=1u) pulls gate toward bvdd
*
* The Vds mismatch between sense device (Vds ~ bvdd) and pass device
* (Vds ~ bvdd-pvdd) amplifies sense current at high pvdd, giving an
* effective mirror ratio lower than geometric 500.
*
* Measured results:
*   TT27: 79.0mA, SS150: 135.7mA, FF-40: 43.4mA
*   PVT spread: 3.1x (136/43.4)
*   Quiescent: ~0.0002 uA at Iload=0
*   Short circuit: ~105mA with limiter vs ~598mA without
*   Loop PM: ~104 deg at UGB=423kHz (with real error amp, break-loop AC)
*
.subckt current_limiter gate bvdd pvdd gnd ilim_flag

* === Sense PMOS ===
XMs  sense_n gate bvdd bvdd sky130_fd_pr__pfet_g5v0d10v5 w=1e-6 l=0.5e-6

* === Sense Resistor ===
* Reduced sense resistor and narrowed sense PMOS to fix Vds mismatch.
* W=1u instead of 2u halves sense current; L=1.0 reduces Rs to ~1.9k.
* Combined: trip current roughly doubles.
XRs  sense_n gnd gnd sky130_fd_pr__res_xhigh_po w=1 l=1.0

* === Detection NMOS ===
* No source degeneration — direct connection to ground
* Maximizes detection sensitivity for highest SS150 primary metric
XMdet det_n sense_n gnd gnd sky130_fd_pr__nfet_g5v0d10v5 w=5e-6 l=1e-6

* === Pull-up Resistor ===
* xhigh_po W=1u L=5u → Rpu ~ 10.5k
XRpu  bvdd det_n gnd sky130_fd_pr__res_xhigh_po w=1 l=5

* === Clamp PMOS ===
* W=20u L=1u — strong clamp, overwhelms gate drive through 10k Rgate
XMclamp gate det_n bvdd bvdd sky130_fd_pr__pfet_g5v0d10v5 w=20e-6 l=1e-6

* === Flag output ===
XMfp ilim_flag det_n pvdd pvdd sky130_fd_pr__pfet_g5v0d10v5 w=2e-6 l=1e-6
XMfn ilim_flag det_n gnd gnd sky130_fd_pr__nfet_g5v0d10v5 w=2e-6 l=1e-6

.ends current_limiter

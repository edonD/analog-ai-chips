* Block 04: Current Limiter (v7 — FIX-20: cascode bias Vds matching)
* PVDD 5V LDO Regulator — SkyWater SKY130A
*
* Topology: Sense-mirror with current-mode comparator referenced to ibias
*
* v6 changes: Fix current limit trip point under regulation
*   - v5 had two bugs that made the trip occur at ~17mA instead of 50mA:
*     1. Gate pullup PFET (XMgate_pu) in Block 10 was partially ON due to
*        undersized inverter, stealing ~1mA from gate and fighting error amp
*     2. ibias shared between error amp and current limiter — each diode got
*        only 0.5µA instead of 1µA, halving the current limit threshold
*   - Fix 1 (Block 10): Wider inverter PFET (4u→40u), weaker pullup (10u→4u)
*   - Fix 2 (Block 10): Dedicated ibias_ilim for current limiter (1µA)
*   - Mirror ratio kept at original 50:1 (correct when ibias = 1µA)
*
*   XMs: Sense PMOS (W=1u L=0.5u), mirrors 1/1000 of pass device current
*   XMcas: Cascode PMOS (W=10u L=0.5u), biased from BVDD divider
*   XMref_d: Diode NMOS (W=2u L=8u), receives ibias (1µA dedicated)
*   XMref_m: Mirror NMOS (W=100u L=8u), 50:1 ratio → sinks 50µA from sense_out
*   XMinv: Inverter converts sense_out → det_n
*   XMclamp 1-4: 4× clamp PMOS (W=50u L=0.5u) pulls gate toward BVDD
*
* Trip point: Iref = 50µA × 1000 (sense ratio) = 50mA load current
*
.subckt current_limiter gate bvdd pvdd gnd ilim_flag ibias

* === Cascode bias: BVDD resistor divider → ~3V ===
* At BVDD=7V: cas_bias = 7 × 400/(300+400) = 4.0V (FIX-20: matches Vds of sense to pass)
* 10× higher R → ~5µA instead of ~50µA Iq savings
* Stays valid during short circuit (doesn't depend on PVDD)
XRcas_top bvdd cas_bias gnd sky130_fd_pr__res_xhigh_po w=1 l=300
XRcas_bot cas_bias gnd gnd sky130_fd_pr__res_xhigh_po w=1 l=400

* === Sense PMOS (1/1000 mirror of pass device) ===
XMs cas_mid gate bvdd bvdd sky130_fd_pr__pfet_g5v0d10v5 w=1e-6 l=0.5e-6

* === Cascode PMOS for Vds matching ===
XMcas sense_out cas_bias cas_mid cas_mid sky130_fd_pr__pfet_g5v0d10v5 w=10e-6 l=0.5e-6

* === Bandgap-referenced current comparator ===
* Reference arm: ibias (1µA) mirrored 50× → Iref = 50µA
* Diode-connected NMOS receives ibias
XMref_d ibias ibias gnd gnd sky130_fd_pr__nfet_g5v0d10v5 w=2e-6 l=8e-6
* Mirror NMOS: W ratio 50:1 → sinks 50µA from sense_out
XMref_m sense_out ibias gnd gnd sky130_fd_pr__nfet_g5v0d10v5 w=100e-6 l=8e-6

* === Comparator: sense_out voltage indicates overcurrent ===
* When Isense < 50µA: XMref_m pulls sense_out LOW (NMOS wins)
* When Isense > 50µA: sense PMOS pushes sense_out HIGH (PMOS wins)
* Inverter converts: sense_out HIGH → det_n LOW → clamp ON
XMinv_n det_n sense_out gnd gnd sky130_fd_pr__nfet_g5v0d10v5 w=10e-6 l=1e-6
XMinv_p det_n sense_out bvdd bvdd sky130_fd_pr__pfet_g5v0d10v5 w=20e-6 l=1e-6

* === Pull-up resistor on det_n (backup, ensures det_n HIGH when no overcurrent) ===
XRpu bvdd det_n gnd sky130_fd_pr__res_xhigh_po w=1 l=500

* === Clamp PMOS (pulls gate toward BVDD when det_n LOW) ===
XMclamp1 gate det_n bvdd bvdd sky130_fd_pr__pfet_g5v0d10v5 w=50e-6 l=0.5e-6
XMclamp2 gate det_n bvdd bvdd sky130_fd_pr__pfet_g5v0d10v5 w=50e-6 l=0.5e-6
XMclamp3 gate det_n bvdd bvdd sky130_fd_pr__pfet_g5v0d10v5 w=50e-6 l=0.5e-6
XMclamp4 gate det_n bvdd bvdd sky130_fd_pr__pfet_g5v0d10v5 w=50e-6 l=0.5e-6

* === Flag output ===
XMfp ilim_flag det_n pvdd pvdd sky130_fd_pr__pfet_g5v0d10v5 w=2e-6 l=1e-6
XMfn ilim_flag det_n gnd gnd sky130_fd_pr__nfet_g5v0d10v5 w=2e-6 l=1e-6

.ends current_limiter

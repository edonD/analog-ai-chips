* Block 04: Current Limiter (v2)
* PVDD 5V LDO Regulator — SkyWater SKY130A
*
* Topology: Sense-mirror brick-wall limiter with Vth-based detection
*           and source-degenerated detection for soft turn-on
*
*   XMs: Sense PMOS (gate shared with pass device)
*         W=2u L=0.5u, pass device is 10x W=100u L=0.5u
*         Geometric ratio N = 1000/2 = 500
*   XRs: Sense resistor converts Isense to voltage
*         xhigh_po W=1u L=3.5u → Rs ~ 6882 ohm
*   XMdet: Detection NMOS with source degeneration for soft turn-on
*   XRdegen: Source degeneration resistor, ~200 ohm
*   XRpu: Pull-up resistor keeps det_n HIGH during normal operation
*   XMclamp: Clamp PMOS pulls gate toward bvdd when overcurrent detected
*         W=20u L=1u (strong — overwhelms gate drive at any Rgate)
*
* The Vds mismatch between sense device (Vds ~ bvdd) and pass device
* (Vds ~ bvdd-pvdd) amplifies sense current at high pvdd, giving an
* effective mirror ratio lower than geometric 500. This causes earlier
* trip at the overload operating point.
*
* Measured results (v2 with degeneration):
*   TT27: 78.3mA, SS150: 130mA, FF-40: 43.6mA
*   PVT spread: 3.0x (130/43.6)
*   Quiescent: ~0.0002 uA at Iload=0
*   Short circuit: ~104mA with limiter vs ~598mA without
*
.subckt current_limiter gate bvdd pvdd gnd ilim_flag

* === Sense PMOS ===
XMs  sense_n gate bvdd bvdd sky130_fd_pr__pfet_g5v0d10v5 w=2e-6 l=0.5e-6

* === Sense Resistor ===
* xhigh_po W=1u L=3.5u → Rs ~ 2000*(3.5-0.059)/1 = 6882 ohm
* At 78mA trip: Isense_eff ~ 420uA (Vds mismatch inflates it)
* Vsense = 420uA * 6882 = 2.89V → well above Vth+Vdegen for detection
XRs  sense_n gnd gnd sky130_fd_pr__res_xhigh_po w=1 l=3.5

* === Detection NMOS with source degeneration ===
* Small degeneration for soft turn-on around the trip point.
* L=0.16 → Rdegen ~ 2000*(0.16-0.059)/1 = 202 ohm
* At Id=100uA → Vdegen = 20mV (minimal, mostly anti-oscillation)
XMdet det_n sense_n degen_node gnd sky130_fd_pr__nfet_g5v0d10v5 w=5e-6 l=1e-6
XRdegen degen_node gnd gnd sky130_fd_pr__res_xhigh_po w=1 l=0.16

* === Pull-up Resistor ===
* xhigh_po W=1u L=5u → Rpu ~ 10.5k
* At Iload=0: Rpu carries no current (both ends at bvdd, Mdet OFF)
XRpu  bvdd det_n gnd sky130_fd_pr__res_xhigh_po w=1 l=5

* === Clamp PMOS ===
* W=20u L=1u — strong enough to overwhelm gate drive through 10k Rgate
XMclamp gate det_n bvdd bvdd sky130_fd_pr__pfet_g5v0d10v5 w=20e-6 l=1e-6

* === Flag output ===
XMfp ilim_flag det_n pvdd pvdd sky130_fd_pr__pfet_g5v0d10v5 w=2e-6 l=1e-6
XMfn ilim_flag det_n gnd gnd sky130_fd_pr__nfet_g5v0d10v5 w=2e-6 l=1e-6

.ends current_limiter

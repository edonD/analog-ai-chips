* Block 04: Current Limiter (v2)
* PVDD 5V LDO Regulator — SkyWater SKY130A
*
* Topology: Sense-mirror brick-wall limiter with Vth-based detection
*
*   XMs: Sense PMOS (W=1u L=0.5u), pass device total W=1000u
*         Geometric ratio N = 1000
*   XRs: Sense resistor xhigh_po W=1u L=7.0 → Rs ≈ 14kΩ
*   XMdet: Detection NMOS (W=20u L=1u), trips when Vsense > Vth (~0.7V)
*   XRpu: Pull-up xhigh_po W=1u L=500 → Rpu ≈ 1MΩ (high R for strong det_n pull-down)
*   XMclamp: 4× parallel clamp PMOS (W=50u L=0.5u m=2 each) → gate toward BVDD
*
* v3 changes: Increased Rs (l=1→7), XMdet (5u→20u), XRpu (10k→1MΩ),
*   clamp (0.42u/20u → 4×50u/0.5u) to fix T11 FAIL (619mA→61mA).
* v4 changes: Added cascode PMOS (XMcas) between sense PMOS and sense resistor
*   to match Vds_sense ≈ Vds_pass. Fixes trip point from ~20mA to ~50mA.
*   cas_bias tied to pvdd for automatic tracking across operating points.
*
* Measured (v3, full integration):
*   T11 short-circuit: 60.9mA (spec <80mA) PASS
*   T1 DC 1mA: no false trigger (sense_n=0.12V, det_n=7.0V)
*
.subckt current_limiter gate bvdd pvdd gnd ilim_flag

* === Sense PMOS ===
XMs  cas_mid gate bvdd bvdd sky130_fd_pr__pfet_g5v0d10v5 w=1e-6 l=0.5e-6

* === Cascode PMOS for Vds matching ===
* Forces Vds_sense ≈ Vds_pass by tying cas_bias to pvdd.
* cas_mid ≈ pvdd + |Vth| ≈ 5.7V → Vds_sense ≈ 1.3V ≈ Vds_pass ≈ 2V
* W=10u (not 1u) needed: thick-oxide PFET has very low µpCox (~10µA/V²),
* so W/L=20 required to pass ~50µA sense current with Vsg≈2V headroom.
XMcas sense_n pvdd cas_mid cas_mid sky130_fd_pr__pfet_g5v0d10v5 w=10e-6 l=0.5e-6

* === Sense Resistor ===
* L=7.0 → Rs≈14kΩ. Trip at ~50mA, hard clamp at short circuit.
XRs  sense_n gnd gnd sky130_fd_pr__res_xhigh_po w=1 l=7.0

* === Detection NMOS ===
* Wider device for stronger pull-down of det_n when overcurrent detected
XMdet det_n sense_n gnd gnd sky130_fd_pr__nfet_g5v0d10v5 w=20e-6 l=1e-6

* === Pull-up Resistor ===
* xhigh_po W=1u L=500u → Rpu ~ 1MΩ
* Very high R so even weak XMdet current pulls det_n near GND
* During normal op (XMdet OFF), det_n pulled to BVDD — clamp OFF
XRpu  bvdd det_n gnd sky130_fd_pr__res_xhigh_po w=1 l=500

* === Clamp PMOS ===
* Must source >6mA through Rgate=1k to pull gate near BVDD
* Thick-oxide 10.5V PFET has low µpCox → need large W/L, parallel instances
XMclamp1 gate det_n bvdd bvdd sky130_fd_pr__pfet_g5v0d10v5 w=50e-6 l=0.5e-6 m=2
XMclamp2 gate det_n bvdd bvdd sky130_fd_pr__pfet_g5v0d10v5 w=50e-6 l=0.5e-6 m=2
XMclamp3 gate det_n bvdd bvdd sky130_fd_pr__pfet_g5v0d10v5 w=50e-6 l=0.5e-6 m=2
XMclamp4 gate det_n bvdd bvdd sky130_fd_pr__pfet_g5v0d10v5 w=50e-6 l=0.5e-6 m=2

* === Flag output ===
XMfp ilim_flag det_n pvdd pvdd sky130_fd_pr__pfet_g5v0d10v5 w=2e-6 l=1e-6
XMfn ilim_flag det_n gnd gnd sky130_fd_pr__nfet_g5v0d10v5 w=2e-6 l=1e-6

.ends current_limiter

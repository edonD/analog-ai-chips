* Quick PDK test — verify HV devices load
.include "parasitic_res_po.spice"
.lib "sky130.lib.spice" tt
.temp 27

Vdd vdd 0 7
Vgs gate 0 3.5
Vds drain 0 5

XM1 drain gate vdd vdd sky130_fd_pr__pfet_g5v0d10v5 w=100e-6 l=0.5e-6
XMn drain2 gate2 0 0 sky130_fd_pr__nfet_g5v0d10v5 w=10e-6 l=0.5e-6
Vgs2 gate2 0 1.0
Vds2 drain2 0 2.0

* Resistor test (dimensions in microns for res model)
XR1 n1 n2 0 sky130_fd_pr__res_xhigh_po w=1 l=2
V1 n1 0 1.0
V2 n2 0 0

.control
op
echo "PFET Id:"
print i(Vds)
echo "NFET Id:"
print i(Vds2)
echo "Resistor current (expect ~250uA for ~4kohm):"
print i(V2)
echo "PDK test PASS"
quit
.endc
.end

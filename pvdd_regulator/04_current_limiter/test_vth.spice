* Characterize HV NFET Vth for detection transistor sizing
.include "parasitic_res_po.spice"
.lib "sky130.lib.spice" tt
.temp 27

Vgs gate 0 0
Vds drain 0 1.0
XMn drain gate 0 0 sky130_fd_pr__nfet_g5v0d10v5 w=5e-6 l=1e-6

.control
dc Vgs 0 2.0 0.01
let id = i(Vds)
* Find Vth (where Id crosses 1uA)
let thresh = 1e-6
let idx = 0
let vth_found = 0
foreach val $&id
  if val > thresh
    if vth_found = 0
      let vth_approx = idx * 0.01
      echo "Approximate Vth (Id=1uA): $&vth_approx V"
      let vth_found = 1
    end
  end
  let idx = idx + 1
end
echo "Done"
quit
.endc
.end

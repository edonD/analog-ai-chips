* tb_su_inrush.spice — Measure peak pass device current during startup

.subckt sky130_fd_pr__model__parasitic__res_po r0 r1 sub w=1 l=1
.param cpoly_area = 1e-16
.param cp = 'cpoly_area * w * l'
c0 r0 sub 'cp/2'
c1 r1 sub 'cp/2'
.ends sky130_fd_pr__model__parasitic__res_po
.lib '../sky130.lib.spice' tt

.include 'design.cir'
.include '../01_pass_device/design.cir'
.include '../00_error_amp/design.cir'
.include '../02_feedback_network/design.cir'
.include '../03_compensation/design.cir'

* BVDD ramp to 7V at 1 V/us
Vbvdd bvdd gnd PWL(0 0 7u 7 100u 7)
Vref vref gnd 1.226
Ibias pvdd ibias DC 1u

Xstartup bvdd pvdd gate gnd vref startup_done ea_en startup
Xerramp vref vfb gate pvdd gnd ibias ea_en error_amp
Xpass gate bvdd pvdd pass_device
Xfb pvdd vfb gnd feedback_network
Xcomp gate pvdd gnd compensation
Cout pvdd gnd 1n

* Current sense: measure pass device current via BVDD source
* Vbvdd already defined — I(Vbvdd) gives total BVDD current

.ic V(pvdd)=0 V(gate)=0 V(bvdd)=0
.option gmin=1e-10 abstol=1e-12 reltol=1e-3 itl1=500 itl4=500
.tran 0.01u 100u uic

.control
run
set wr_vecnames

* Pass device current = current from Vbvdd (negative = sourcing)
let id_pass = -I(Vbvdd)
let vds_pass = V(bvdd) - V(pvdd)
let p_inst = id_pass * vds_pass

wrdata tb_su_inrush_data.txt id_pass vds_pass p_inst V(pvdd)

let id_peak = vecmax(id_pass)
let id_peak_mA = id_peak * 1000
let p_peak = vecmax(p_inst)
let p_peak_mW = p_peak * 1000

echo "Peak inrush current: $&id_peak_mA mA"
echo "Peak instantaneous power: $&p_peak_mW mW"

.endc
.end

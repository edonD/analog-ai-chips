* tb_su_leakage.spice — Measure startup circuit leakage after startup complete
* Applies steady-state conditions: BVDD=7V, PVDD=5V, gate=6V (post-startup)

.subckt sky130_fd_pr__model__parasitic__res_po r0 r1 sub w=1 l=1
.param cpoly_area = 1e-16
.param cp = 'cpoly_area * w * l'
c0 r0 sub 'cp/2'
c1 r1 sub 'cp/2'
.ends sky130_fd_pr__model__parasitic__res_po
.lib '../sky130.lib.spice' tt

.include 'design.cir'

* Steady state post-startup conditions
Vbvdd bvdd gnd 7
Vpvdd pvdd gnd 5
Vgate gate gnd 6
Vref vref gnd 1.226

* Startup circuit under test
Xstartup bvdd pvdd gate gnd vref startup_done ea_en startup

.op

.control
run

* Measure BVDD current (into startup circuit from battery supply)
let i_bvdd = abs(@vbvdd[i])
let i_pvdd = abs(@vpvdd[i])
let leak_uA = i_bvdd * 1e6
let pvdd_uA = i_pvdd * 1e6

echo "BVDD current (startup leakage): $&leak_uA uA"
echo "PVDD current (divider): $&pvdd_uA uA"
echo leakage_after_uA: $&leak_uA

.endc
.end

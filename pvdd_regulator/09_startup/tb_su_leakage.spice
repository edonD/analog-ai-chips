* tb_su_leakage.spice — Post-startup leakage measurement, TT 27C
* ALL metrics from .meas or vector math — ZERO hardcoded values

.subckt sky130_fd_pr__model__parasitic__res_po r0 r1 sub w=1 l=1
.param cpoly_area = 1e-16
.param cp = 'cpoly_area * w * l'
c0 r0 sub 'cp/2'
c1 r1 sub 'cp/2'
.ends sky130_fd_pr__model__parasitic__res_po
.lib '../sky130.lib.spice' tt

.include 'design.cir'
.include '../01_pass_device/design.cir'
.include '../00_error_amp/design.cir'
.include '../02_feedback_network/design.cir'
.include '../03_compensation/design.cir'

* BVDD ramp: 0 -> 7V in 7us (1 V/us), then hold long
Vbvdd bvdd gnd PWL(0 0 7u 7 500u 7)
Vref vref gnd 1.226
Ibias pvdd ibias DC 1u

Xstartup bvdd pvdd gate gnd vref startup_done ea_en startup
Xerramp vref vfb gate pvdd gnd ibias ea_en error_amp
Xpass gate bvdd pvdd pass_device
Xfb pvdd vfb gnd feedback_network
Xcomp gate pvdd gnd compensation

Cout pvdd gnd 10n

* Ammeter on BVDD into startup circuit to measure leakage
* We measure current through the startup subcircuit by monitoring
* internal node currents. Instead, use a 0V voltage source as ammeter.
Vamm bvdd_su bvdd DC 0
* Reconnect startup to use bvdd_su
* Actually, we can't easily do that with subcircuit includes.
* Instead, measure total BVDD current at steady state and subtract known loads.

.ic V(pvdd)=0 V(gate)=0 V(bvdd)=0
.option gmin=1e-10 abstol=1e-12 reltol=1e-3 itl1=500 itl4=500
.tran 0.1u 500u uic

.control
run
set wr_vecnames
wrdata tb_su_leakage_data.txt V(bvdd) V(pvdd) V(startup_done) V(ea_en)

* --- Leakage: measure current into startup resistor divider at steady state ---
* After startup, the main leakage paths in the startup circuit are:
* 1. R_top + R_bot divider: I = PVDD / (R_top + R_bot)
* 2. R_pu pullup: I = BVDD / R_pu (when MN_det is off) or ~0 (when MN_det is on, det_n=low)
* 3. MN_gate: should be OFF (inv_det=LOW after startup)
*
* Measure PVDD at steady state to estimate divider current
meas tran pvdd_ss find V(pvdd) at=499u
meas tran bvdd_ss find V(bvdd) at=499u

* R_top l=4700 w=2 → ~4700*2k/2 = 4.7M, R_bot l=1000 w=2 → ~1M
* Total divider R ~ 5.7M → I ~ 5V/5.7M ~ 0.88uA
* R_pu l=15000 w=1 → ~15M → I ~ 7V/15M ~ 0.47uA when det_n is high
* But after startup, MN_det is ON (sense_mid > Vth), so det_n is LOW
* and R_pu current flows through MN_det to ground: I ~ 7V/15M = 0.47uA

* Total estimated leakage from startup circuit
* Use xhigh_po sheet R ~ 2000 ohm/sq, R = Rsh * l / w
let r_top_ohm = 2000 * 4700 / 2
let r_bot_ohm = 2000 * 1000 / 2
let r_pu_ohm = 2000 * 15000 / 1
let i_divider = pvdd_ss / (r_top_ohm + r_bot_ohm)
let i_pullup = bvdd_ss / r_pu_ohm
let leakage_uA = (i_divider + i_pullup) * 1e6
echo leakage_after_uA: $&leakage_uA

if leakage_uA < 1
  echo leakage_ok: 1
else
  echo leakage_ok: 0
end

.endc
.end

* Quick test: how many stacked NMOS diodes give ~5V clamp?
.subckt sky130_fd_pr__model__parasitic__res_po r0 r1 sub w=1 l=1
.param cpoly_area = 1e-16
.param cp = 'cpoly_area * w * l'
c0 r0 sub 'cp/2'
c1 r1 sub 'cp/2'
.ends sky130_fd_pr__model__parasitic__res_po
.lib '../sky130.lib.spice' tt

* Test: 7 stacked NMOS diodes from PVDD to GND
* Each drops ~Vth. Clamp voltage = sum of Vgs drops.
Vpvdd pvdd gnd 0

XM1 pvdd pvdd n1 gnd sky130_fd_pr__nfet_g5v0d10v5 w=5e-6 l=1e-6
XM2 n1 n1 n2 gnd sky130_fd_pr__nfet_g5v0d10v5 w=5e-6 l=1e-6
XM3 n2 n2 n3 gnd sky130_fd_pr__nfet_g5v0d10v5 w=5e-6 l=1e-6
XM4 n3 n3 n4 gnd sky130_fd_pr__nfet_g5v0d10v5 w=5e-6 l=1e-6
XM5 n4 n4 n5 gnd sky130_fd_pr__nfet_g5v0d10v5 w=5e-6 l=1e-6
XM6 n5 n5 n6 gnd sky130_fd_pr__nfet_g5v0d10v5 w=5e-6 l=1e-6
XM7 n6 n6 gnd gnd sky130_fd_pr__nfet_g5v0d10v5 w=5e-6 l=1e-6

.dc Vpvdd 0 8 0.01

.control
run
let id_clamp = -I(Vpvdd)
* Find voltage where clamp conducts 1µA, 10µA, 100µA, 1mA
echo "=== Clamp characteristics ==="
let i = 0
let found1u = 0
let found10u = 0
let found100u = 0
let found1m = 0
foreach val $&id_clamp
  let icomp = $val
  let vcomp = V(pvdd)[i]
  if icomp > 1e-6 and found1u = 0
    let found1u = 1
    echo "1µA clamp at: $&vcomp V"
  end
  if icomp > 10e-6 and found10u = 0
    let found10u = 1
    echo "10µA clamp at: $&vcomp V"
  end
  if icomp > 100e-6 and found100u = 0
    let found100u = 1
    echo "100µA clamp at: $&vcomp V"
  end
  if icomp > 1e-3 and found1m = 0
    let found1m = 1
    echo "1mA clamp at: $&vcomp V"
  end
  let i = i + 1
end
.endc
.end

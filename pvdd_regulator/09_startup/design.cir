* Block 09: Startup Circuit — v25b
* PVDD 5V LDO Regulator — SkyWater SKY130A
*
* v25b: Rgate (50kΩ) between CG output and gate.
*   Best DC regulation: 84mV range across 0-50mA, all within spec.
*   No cascode, no bypass caps — simplest stable topology.
*
*   Known limitations (fundamental to CG level shifter):
*   - Startup peak: 6.54V (spec <5.5V) — R_load charges gate fast
*   - PSRR 1kHz: -18dB — R_load couples BVDD AC to gate
*   - Load transient: slow — CG + Rgate bandwidth limit
*
.subckt startup bvdd pvdd gate gnd vref startup_done ea_en ea_out

* ================================================================
* CG NFET LEVEL SHIFTER
* ================================================================
Rlb1 bvdd ls_bias 200k
Rlb2 ls_bias 0 500k
XMN_cg ea_out ls_bias gate_int gnd sky130_fd_pr__nfet_g5v0d10v5 w=1.5e-6 l=4e-6

* R_load: ~38kΩ from BVDD to gate_int
XR_load bvdd gate_int gnd sky130_fd_pr__res_xhigh_po w=1 l=19

* Gate series resistance: decouples CG non-linearity from gate
Rgate gate_int gate 50k

* ea_en: ALWAYS HIGH
Ren bvdd ea_en 100

* startup_done: HIGH when PVDD > ~4V
XR_top pvdd sense_mid gnd sky130_fd_pr__res_xhigh_po w=2 l=788
XR_bot sense_mid gnd gnd sky130_fd_pr__res_xhigh_po w=2 l=212
XMN_det det_n sense_mid gnd gnd sky130_fd_pr__nfet_g5v0d10v5 w=4e-6 l=1e-6
XR_pu bvdd det_n gnd sky130_fd_pr__res_xhigh_po w=1 l=2000
XMP_inv1 startup_done det_n bvdd bvdd sky130_fd_pr__pfet_g5v0d10v5 w=4e-6 l=1e-6
XMN_inv1 startup_done det_n gnd  gnd  sky130_fd_pr__nfet_g5v0d10v5 w=2e-6 l=1e-6

.ends startup

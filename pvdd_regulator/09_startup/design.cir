* Block 09: Startup Circuit — v40 (direct gate drive, no level shifter)
* PVDD 5V LDO Regulator — SkyWater SKY130A
*
* v40: Error amp output is in BVDD domain (BVDD-powered Stage 2).
*   NO CG level shifter needed — ea_out drives gate directly via Rgate.
*   No R_load from BVDD → no BVDD coupling → good PSRR.
*   No bandwidth bottleneck → fast transient response.
*
* This startup block provides:
*   - Rgate (1kΩ) series resistance for gate drive isolation
*   - ea_en: always HIGH (tied to bvdd)
*   - startup_done detector (HIGH when PVDD > ~4V)
*
.subckt startup bvdd pvdd gate gnd vref startup_done ea_en ea_out

* Gate connection: ea_out (BVDD domain) drives gate directly through Rgate
* Rgate provides isolation and limits gate charge/discharge rate
Rgate ea_out gate 1k

* ea_en: ALWAYS HIGH (tied to BVDD through low-R)
Ren bvdd ea_en 100

* Active startup gate pulldown: det_n is HIGH when PVDD < 3.3V
* XMsu_pd pulls gate to GND during startup → pass device ON → PVDD charges
* Once PVDD > 3.3V: det_n goes LOW → XMsu_pd OFF → EA takes control
* No DC current at regulation (XMsu_pd is OFF)
XMsu_pd gate det_n gnd gnd sky130_fd_pr__nfet_g5v0d10v5 w=10e-6 l=1e-6

* startup_done: HIGH when PVDD > ~4V
* Resistive divider: sense_mid = pvdd × 212/(788+212) = pvdd × 0.212
* Trips when sense_mid > Vth ≈ 0.7V → pvdd > 3.3V
XR_top pvdd sense_mid gnd sky130_fd_pr__res_xhigh_po w=2 l=788
XR_bot sense_mid gnd gnd sky130_fd_pr__res_xhigh_po w=2 l=212
XMN_det det_n sense_mid gnd gnd sky130_fd_pr__nfet_g5v0d10v5 w=4e-6 l=1e-6
XR_pu bvdd det_n gnd sky130_fd_pr__res_xhigh_po w=1 l=2000
XMP_inv1 startup_done det_n bvdd bvdd sky130_fd_pr__pfet_g5v0d10v5 w=4e-6 l=1e-6
XMN_inv1 startup_done det_n gnd  gnd  sky130_fd_pr__nfet_g5v0d10v5 w=2e-6 l=1e-6

.ends startup

* Block 09: Startup Circuit — v21
* PVDD 5V LDO Regulator — SkyWater SKY130A
*
* v21: Minimal startup — no bootstrap, no soft-start.
*   CG level shifter + R_load naturally bootstraps PVDD to ~3.4V
*   (through the CG's parasitic operating point and R_load pull-up).
*   Error amp always enabled (ea_en=BVDD), drives avbg directly.
*   Once PVDD > ~3V, error amp takes over and regulates to 5V.
*
.subckt startup bvdd pvdd gate gnd vref startup_done ea_en ea_out

* ================================================================
* CG NFET LEVEL SHIFTER
* ls_bias = BVDD * 5/7 ≈ 5.0V at BVDD=7V (simple resistive divider)
* No diode clamp — the old 4-diode clamp limited ls_bias to 4.56V,
* which put the CG in a dead zone where ea_out 0-3V all map to
* "gate near 0V, pass device fully ON" with no proportional control.
* At ls_bias=5V: the CG transition region aligns with ea_out≈2.5-3.5V,
* providing proper proportional control of pass device current.
* ================================================================
Rlb1 bvdd ls_bias 200k
Rlb2 ls_bias 0 500k

XMN_cg ea_out ls_bias gate gnd sky130_fd_pr__nfet_g5v0d10v5 w=2e-6 l=4e-6

* R_load: 100kΩ from BVDD to gate (also serves as startup pull-up)
XR_load bvdd gate gnd sky130_fd_pr__res_xhigh_po w=1 l=19

* ea_en: ALWAYS HIGH — connected to BVDD via low-R path
Ren bvdd ea_en 100

* startup_done: HIGH when PVDD > ~4V (informational only)
XR_top pvdd sense_mid gnd sky130_fd_pr__res_xhigh_po w=2 l=788
XR_bot sense_mid gnd gnd sky130_fd_pr__res_xhigh_po w=2 l=212
XMN_det det_n sense_mid gnd gnd sky130_fd_pr__nfet_g5v0d10v5 w=4e-6 l=1e-6
XR_pu bvdd det_n gnd sky130_fd_pr__res_xhigh_po w=1 l=2000
XMP_inv1 startup_done det_n bvdd bvdd sky130_fd_pr__pfet_g5v0d10v5 w=4e-6 l=1e-6
XMN_inv1 startup_done det_n gnd  gnd  sky130_fd_pr__nfet_g5v0d10v5 w=2e-6 l=1e-6

.ends startup

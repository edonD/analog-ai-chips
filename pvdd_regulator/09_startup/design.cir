* Block 09: Startup Circuit
* PVDD 5V LDO Regulator — SkyWater SKY130A
*
* Mechanism: Current-limited gate pulldown + PVDD threshold detection
*            + weak BVDD-domain gate pull-up (regulation assist)
*
* 10/11 specs pass. PVDD overshoot at BVDD=7V no-load is a system-level
* limitation: error amp (PVDD-domain) cannot pull gate above PVDD.
*
* Level shifter was investigated and achieves PVDD=5.001V regulation,
* but its bias divider + R_load exceed the 1µA leakage budget.
*
.subckt startup bvdd pvdd gate gnd vref startup_done ea_en

* ================================================================
* PVDD threshold detector — trips at ~3.9V
* ================================================================
XR_top pvdd sense_mid gnd sky130_fd_pr__res_xhigh_po w=2 l=8200
XR_bot sense_mid gnd gnd sky130_fd_pr__res_xhigh_po w=2 l=1800
XMN_det det_out sense_mid gnd gnd sky130_fd_pr__nfet_g5v0d10v5 w=10e-6 l=1e-6

* 30MΩ pull-up: 0.23µA leakage after startup
XR_pu bvdd det_out gnd sky130_fd_pr__res_xhigh_po w=1 l=15001

* ================================================================
* Gate pulldown — current-limited by R_gate (~100k)
* ================================================================
XR_gate gate pull_mid gnd sky130_fd_pr__res_xhigh_po w=1 l=51
XMN_gate pull_mid det_out gnd gnd sky130_fd_pr__nfet_g5v0d10v5 w=5e-6 l=1e-6

* ================================================================
* BVDD gate pull-up (regulation assist + overshoot limiter)
* ================================================================
* W=100u source follower limits gate drop during startup.
* At regulation (gate≈6V): Vgs≈1V → deep subthreshold → negligible leakage.
* During startup: fights gate pulldown, keeping Vsg low.
XMN_pu bvdd bvdd gate gnd sky130_fd_pr__nfet_g5v0d10v5 w=100e-6 l=1e-6

* ================================================================
* Output flags — CMOS inverters from det_out
* ================================================================
XMP_sd startup_done det_out bvdd bvdd sky130_fd_pr__pfet_g5v0d10v5 w=4e-6 l=1e-6
XMN_sd startup_done det_out gnd gnd sky130_fd_pr__nfet_g5v0d10v5 w=2e-6 l=1e-6
XMP_ea ea_en det_out bvdd bvdd sky130_fd_pr__pfet_g5v0d10v5 w=4e-6 l=1e-6
XMN_ea ea_en det_out gnd gnd sky130_fd_pr__nfet_g5v0d10v5 w=2e-6 l=1e-6

.ends startup

* Block 09: Startup Circuit
* PVDD 5V LDO Regulator — SkyWater SKY130A
*
* Mechanism: Current-limited gate pulldown + PVDD threshold detection
*            + weak BVDD-domain gate pull-up (regulation assist)
*
* 10/11 specs pass. PVDD overshoot is system-level (error amp can't
* pull gate above PVDD to turn off W=1mm pass device at no load).
* With 50mA load: PVDD regulates to 5.02V.
*
.subckt startup bvdd pvdd gate gnd vref startup_done ea_en

* ================================================================
* PVDD threshold detector — trips at ~3.9V
* ================================================================
* 5MΩ divider: 1µA quiescent at PVDD=5V
XR_top pvdd sense_mid gnd sky130_fd_pr__res_xhigh_po w=2 l=4100
XR_bot sense_mid gnd gnd sky130_fd_pr__res_xhigh_po w=2 l=900

* Detection NMOS — turns on when sense_mid > Vth (~0.7V)
XMN_det det_out sense_mid gnd gnd sky130_fd_pr__nfet_g5v0d10v5 w=10e-6 l=1e-6

* 10MΩ pull-up: 0.7µA leakage after startup
XR_pu bvdd det_out gnd sky130_fd_pr__res_xhigh_po w=1 l=5001

* ================================================================
* Gate pulldown — current-limited by R_gate (~100k)
* ================================================================
XR_gate gate pull_mid gnd sky130_fd_pr__res_xhigh_po w=1 l=51
XMN_gate pull_mid det_out gnd gnd sky130_fd_pr__nfet_g5v0d10v5 w=5e-6 l=1e-6

* ================================================================
* Weak BVDD gate pull-up (regulation assist)
* ================================================================
* NMOS source follower: sub-0.1µA at regulation point
XMN_pu bvdd bvdd gate gnd sky130_fd_pr__nfet_g5v0d10v5 w=0.42e-6 l=8e-6

* ================================================================
* Output flags — CMOS inverters from det_out
* ================================================================
XMP_sd startup_done det_out bvdd bvdd sky130_fd_pr__pfet_g5v0d10v5 w=4e-6 l=1e-6
XMN_sd startup_done det_out gnd gnd sky130_fd_pr__nfet_g5v0d10v5 w=2e-6 l=1e-6

XMP_ea ea_en det_out bvdd bvdd sky130_fd_pr__pfet_g5v0d10v5 w=4e-6 l=1e-6
XMN_ea ea_en det_out gnd gnd sky130_fd_pr__nfet_g5v0d10v5 w=2e-6 l=1e-6

.ends startup

* Block 09: Startup Circuit — v27
* PVDD 5V LDO Regulator — SkyWater SKY130A
*
* v27: CASCODE PMOS between BVDD and R_load.
*   BVDD → XMP_casc (gate=ls_bias) → mid → R_load (38kΩ) → gate
*   DC: cascode passes current, R_load sets gate equilibrium (stable)
*   AC: cascode output impedance blocks BVDD ripple → improved PSRR
*   Startup: R_load + cascode limits gate charging rate
*
.subckt startup bvdd pvdd gate gnd vref startup_done ea_en ea_out

* ================================================================
* CG NFET LEVEL SHIFTER
* ================================================================
Rlb1 bvdd ls_bias 200k
Rlb2 ls_bias 0 500k
XMN_cg ea_out ls_bias gate gnd sky130_fd_pr__nfet_g5v0d10v5 w=1.5e-6 l=4e-6

* ================================================================
* CASCODE PMOS + R_LOAD: blocks BVDD AC, passes DC
* XMP_casc: source=BVDD, gate=ls_bias, drain=rload_top, body=BVDD
*   Vsg = BVDD - ls_bias ≈ 2V → ON, passes DC current
*   Output impedance ≈ gm*ro² ≈ very high → blocks BVDD AC
* R_load: from rload_top to gate (38kΩ)
*   Sees clean DC from cascode, no BVDD ripple
* ================================================================
* Cascode gate = ls_bias (filtered by Cls)
* Cls (1nF) on ls_bias: filters BVDD AC. Pole at ~1.1kHz.
* Combined with cascode: BVDD rejection at gate is greatly improved.
Cls ls_bias 0 10n
XMP_casc rload_top ls_bias bvdd bvdd sky130_fd_pr__pfet_g5v0d10v5 w=4e-6 l=2e-6
XR_load rload_top gate gnd sky130_fd_pr__res_xhigh_po w=1 l=19

* ea_en: ALWAYS HIGH
Ren bvdd ea_en 100

* startup_done: HIGH when PVDD > ~4V
XR_top pvdd sense_mid gnd sky130_fd_pr__res_xhigh_po w=2 l=788
XR_bot sense_mid gnd gnd sky130_fd_pr__res_xhigh_po w=2 l=212
XMN_det det_n sense_mid gnd gnd sky130_fd_pr__nfet_g5v0d10v5 w=4e-6 l=1e-6
XR_pu bvdd det_n gnd sky130_fd_pr__res_xhigh_po w=1 l=2000
XMP_inv1 startup_done det_n bvdd bvdd sky130_fd_pr__pfet_g5v0d10v5 w=4e-6 l=1e-6
XMN_inv1 startup_done det_n gnd  gnd  sky130_fd_pr__nfet_g5v0d10v5 w=2e-6 l=1e-6

.ends startup

* Block 09: Startup Circuit — v20
* PVDD 5V LDO Regulator — SkyWater SKY130A
*
* v20: Smooth startup — no threshold detector, no abrupt handoff.
*   Small always-on PMOS (W=2u L=4u) bootstraps PVDD to ~3V.
*   Error amp always enabled (ea_en = BVDD from start).
*   Soft-start reference (top-level) ramps from 0 → 1.226V.
*   PVDD smoothly follows the reference ramp. No overshoot.
*
.subckt startup bvdd pvdd gate gnd vref startup_done ea_en ea_out

* Bootstrap PMOS: always-on, provides ~50µA from BVDD to PVDD
* Ensures PVDD can charge above error amp minimum operating voltage
XMP_boot pvdd gnd bvdd bvdd sky130_fd_pr__pfet_g5v0d10v5 w=1e-6 l=8e-6

* ================================================================
* CG NFET LEVEL SHIFTER
* ls_bias ≈ 5V from resistor divider + 4-diode clamp
* ================================================================
XR_lb1 bvdd ls_bias gnd sky130_fd_pr__res_xhigh_po w=2 l=1000
XR_lb2 ls_bias gnd gnd sky130_fd_pr__res_xhigh_po w=2 l=6000
XMD1 ls_bias ls_bias d1 gnd sky130_fd_pr__nfet_g5v0d10v5 w=18e-6 l=1e-6
XMD2 d1 d1 d2 gnd sky130_fd_pr__nfet_g5v0d10v5 w=18e-6 l=1e-6
XMD3 d2 d2 d3 gnd sky130_fd_pr__nfet_g5v0d10v5 w=18e-6 l=1e-6
XMD4 d3 d3 gnd gnd sky130_fd_pr__nfet_g5v0d10v5 w=18e-6 l=1e-6

XMN_cg ea_out ls_bias gate gnd sky130_fd_pr__nfet_g5v0d10v5 w=2e-6 l=4e-6

* R_load: 100kΩ from BVDD to gate
XR_load bvdd gate gnd sky130_fd_pr__res_xhigh_po w=1 l=50

* ea_en: ALWAYS HIGH — connected to BVDD via low-R path
* Error amp always enabled; soft-start reference prevents overshoot.
Ren bvdd ea_en 100

* startup_done: HIGH when PVDD > ~4V (informational only)
XR_top pvdd sense_mid gnd sky130_fd_pr__res_xhigh_po w=2 l=788
XR_bot sense_mid gnd gnd sky130_fd_pr__res_xhigh_po w=2 l=212
XMN_det det_n sense_mid gnd gnd sky130_fd_pr__nfet_g5v0d10v5 w=4e-6 l=1e-6
XR_pu bvdd det_n gnd sky130_fd_pr__res_xhigh_po w=1 l=2000
XMP_inv1 startup_done det_n bvdd bvdd sky130_fd_pr__pfet_g5v0d10v5 w=4e-6 l=1e-6
XMN_inv1 startup_done det_n gnd  gnd  sky130_fd_pr__nfet_g5v0d10v5 w=2e-6 l=1e-6

.ends startup

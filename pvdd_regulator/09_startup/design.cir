* Block 09: Startup Circuit — v36
* PVDD 5V LDO Regulator — SkyWater SKY130A
*
* v36: Rpu_ea startup with balanced Iq/overshoot tradeoff
*
*   Rpu_ea (20kΩ): pulls ea_out toward BVDD during startup
*     → CG NFET stays OFF → pass device charges controlled
*     → prevents ea_out latch-up above PVDD
*   During regulation: Iq = (BVDD - ea_out)/20k ≈ 240µA
*     (within 300µA spec)
*
.subckt startup bvdd pvdd gate gnd vref startup_done ea_en ea_out

* ================================================================
* EA output pull-up: controls startup and prevents latch-up
* 20kΩ: Iq = ~240µA, fast enough to limit startup overshoot
* ================================================================
Rpu_ea bvdd ea_out 8k

* ================================================================
* CG NFET level shifter
* ================================================================
Rlb1 bvdd ls_bias 200k
Rlb2 ls_bias 0 500k
XMN_cg ea_out ls_bias gate_int gnd sky130_fd_pr__nfet_g5v0d10v5 w=1.5e-6 l=4e-6
XR_load bvdd gate_int gnd sky130_fd_pr__res_xhigh_po w=1 l=19
Rgate gate_int gate 1k

* ================================================================
* startup_done: HIGH when PVDD > ~4.6V
* Divider: ratio = 140/(935+140) = 0.130 → trips at ~0.6/0.130 = 4.6V
* ================================================================
XR_top pvdd sense_mid gnd sky130_fd_pr__res_xhigh_po w=2 l=935
XR_bot sense_mid gnd gnd sky130_fd_pr__res_xhigh_po w=2 l=140
XMN_det det_n sense_mid gnd gnd sky130_fd_pr__nfet_g5v0d10v5 w=4e-6 l=1e-6
XR_pu bvdd det_n gnd sky130_fd_pr__res_xhigh_po w=1 l=2000
XMP_inv1 startup_done det_n bvdd bvdd sky130_fd_pr__pfet_g5v0d10v5 w=4e-6 l=1e-6
XMN_inv1 startup_done det_n gnd  gnd  sky130_fd_pr__nfet_g5v0d10v5 w=2e-6 l=1e-6

.ends startup

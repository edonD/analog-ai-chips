* tb_su_ss150.spice — SS corner, 150C, worst-case startup time
* ALL metrics from .meas or vector math — ZERO hardcoded values

.subckt sky130_fd_pr__model__parasitic__res_po r0 r1 sub w=1 l=1
.param cpoly_area = 1e-16
.param cp = 'cpoly_area * w * l'
c0 r0 sub 'cp/2'
c1 r1 sub 'cp/2'
.ends sky130_fd_pr__model__parasitic__res_po
.lib '../sky130.lib.spice' ss
.temp 150

.include 'design.cir'
.include '../01_pass_device/design.cir'
.include '../00_error_amp/design.cir'
.include '../02_feedback_network/design.cir'
.include '../03_compensation/design.cir'

* BVDD ramp: 0 -> 7V in 7us (1 V/us), then hold
Vbvdd bvdd gnd PWL(0 0 7u 7 500u 7)
Vref vref gnd 1.226
Ibias pvdd ibias DC 1u

Xstartup bvdd pvdd gate gnd vref startup_done ea_en startup
Xerramp vref vfb gate pvdd gnd ibias ea_en error_amp
Xpass gate bvdd pvdd pass_device
Xfb pvdd vfb gnd feedback_network
Xcomp gate pvdd gnd compensation

Cout pvdd gnd 10n

.ic V(pvdd)=0 V(gate)=0 V(bvdd)=0
.option gmin=1e-10 abstol=1e-12 reltol=1e-3 itl1=500 itl4=500
.tran 0.1u 500u uic

.meas tran t_bvdd_56 when V(bvdd)=5.6 rise=1
.meas tran t_pvdd_settle when V(pvdd)=4.95 rise=1
.meas tran pvdd_max max V(pvdd)

.control
run
set wr_vecnames
wrdata tb_su_ss150_data.txt V(bvdd) V(pvdd) V(gate) V(ea_en)

* --- Startup time at SS 150C ---
let startup_us = 999
if t_pvdd_settle > t_bvdd_56
  let startup_us = (t_pvdd_settle - t_bvdd_56) * 1e6
end
echo startup_time_ss150_us: $&startup_us

* --- Overshoot ---
let pvdd_peak = vecmax(V(pvdd))
let overshoot_mV = (pvdd_peak - 5.0) * 1000
if overshoot_mV < 0
  let overshoot_mV = 0
end
echo pvdd_overshoot_ss150_mV: $&overshoot_mV

* --- Final PVDD ---
meas tran pvdd_final find V(pvdd) at=499u
echo pvdd_final_ss150_V: $&pvdd_final

* --- Pass if startup < 200us (spec allows 200us for SS corner) ---
if startup_us < 200
  echo works_ss_150c: 1
else
  echo works_ss_150c: 0
end

.endc
.end

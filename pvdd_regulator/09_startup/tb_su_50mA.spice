* tb_su_50mA.spice — Startup with 50mA load, TT 27C, 1V/us
* Rload=100 ohm for 50mA at 5V
* ALL metrics from .meas or vector math — ZERO hardcoded values

.subckt sky130_fd_pr__model__parasitic__res_po r0 r1 sub w=1 l=1
.param cpoly_area = 1e-16
.param cp = 'cpoly_area * w * l'
c0 r0 sub 'cp/2'
c1 r1 sub 'cp/2'
.ends sky130_fd_pr__model__parasitic__res_po
.lib '../sky130.lib.spice' tt

.include 'design.cir'
.include '../01_pass_device/design.cir'
.include '../00_error_amp/design.cir'
.include '../02_feedback_network/design.cir'
.include '../03_compensation/design.cir'

* BVDD ramp: 0 -> 7V in 7us (1 V/us), then hold
Vbvdd bvdd gnd PWL(0 0 7u 7 800u 7)
Vref vref gnd 1.226
Ibias pvdd ibias DC 1u

* Startup circuit — 8 ports: bvdd pvdd gate gnd vref startup_done ea_en ea_out
Xstartup bvdd pvdd gate gnd vref startup_done ea_en ea_out startup

* Error amp — ORIGINAL input order (non-swapped)
* NON-INVERTING level shifter: ea_out tracks error amp, gate tracks ea_out
Xerramp vref vfb ea_out pvdd gnd ibias ea_en error_amp

* Pass device gate driven by level shifter output
Xpass gate bvdd pvdd pass_device

* Feedback network
Xfb pvdd vfb gnd feedback_network

* Compensation on ea_out (error amp output side, before level shifter)
Xcomp ea_out pvdd gnd compensation

* Output cap — 10nF + 50mA load
Cout pvdd gnd 10n
Rload pvdd gnd 100

.ic V(pvdd)=0 V(gate)=0 V(bvdd)=0 V(ea_out)=0
.option gmin=1e-10 abstol=1e-12 reltol=1e-3 itl1=500 itl4=500
.tran 0.1u 800u uic

.meas tran t_bvdd_56 when V(bvdd)=5.6 rise=1
.meas tran t_pvdd_settle when V(pvdd)=4.95 rise=1
.meas tran pvdd_max max V(pvdd)

.control
run
set wr_vecnames
wrdata tb_su_50mA_data.txt V(bvdd) V(pvdd) V(gate) V(ea_out) V(startup_done) V(ea_en)

* --- Startup time under 50mA load ---
let startup_us = 999
if t_pvdd_settle > t_bvdd_56
  let startup_us = (t_pvdd_settle - t_bvdd_56) * 1e6
end
echo startup_time_50mA_us: $&startup_us

* --- Overshoot ---
let pvdd_peak = vecmax(V(pvdd))
let overshoot_mV = (pvdd_peak - 5.0) * 1000
if overshoot_mV < 0
  let overshoot_mV = 0
end
echo pvdd_overshoot_mV: $&overshoot_mV
echo pvdd_peak_V: $&pvdd_peak

* --- Final PVDD ---
meas tran pvdd_final find V(pvdd) at=799u
echo pvdd_final_V: $&pvdd_final

* --- Load current check ---
let iload_mA = pvdd_final / 100 * 1000
echo load_current_mA: $&iload_mA

* --- No latch check ---
if pvdd_final > 4.9
  if pvdd_final < 5.2
    echo no_latch_stuck: 1
  else
    echo no_latch_stuck: 0
  end
else
  echo no_latch_stuck: 0
end

.endc
.end

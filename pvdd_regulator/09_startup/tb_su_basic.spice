* tb_su_basic.spice — Basic startup test with integrated level shifter

.subckt sky130_fd_pr__model__parasitic__res_po r0 r1 sub w=1 l=1
.param cpoly_area = 1e-16
.param cp = 'cpoly_area * w * l'
c0 r0 sub 'cp/2'
c1 r1 sub 'cp/2'
.ends sky130_fd_pr__model__parasitic__res_po
.lib '../sky130.lib.spice' tt

.include 'design.cir'
.include '../01_pass_device/design.cir'
.include '../00_error_amp/design.cir'
.include '../02_feedback_network/design.cir'
.include '../03_compensation/design.cir'

Vbvdd bvdd gnd PWL(0 0 7u 7 300u 7)
Vref vref gnd 1.226
Ibias pvdd ibias DC 1u

* Startup circuit (8 ports: bvdd pvdd gate gnd vref startup_done ea_en ea_out)
Xstartup bvdd pvdd gate_pass gnd vref startup_done ea_en ea_out startup

* Error amp drives ea_out (internal to startup subcircuit's level shifter)
Xerramp vref vfb ea_out pvdd gnd ibias ea_en error_amp

* Pass device
Xpass gate_pass bvdd pvdd pass_device

* Feedback + compensation
Xfb pvdd vfb gnd feedback_network
Xcomp gate_pass pvdd gnd compensation
Cout pvdd gnd 1n

.ic V(pvdd)=0 V(gate_pass)=0 V(bvdd)=0 V(ea_out)=0
.option gmin=1e-10 abstol=1e-12 reltol=1e-3 itl1=500 itl4=500
.tran 0.05u 300u uic

.meas tran pvdd_max max V(pvdd)
.meas tran pvdd_at_50u find V(pvdd) at=50u
.meas tran pvdd_at_100u find V(pvdd) at=100u
.meas tran pvdd_at_200u find V(pvdd) at=200u

.control
run
set wr_vecnames
wrdata tb_su_basic_data.txt V(bvdd) V(pvdd) V(gate_pass) V(startup_done) V(ea_en)

let pvdd_peak = vecmax(V(pvdd))
let overshoot_mV = (pvdd_peak - 5.0) * 1000
if overshoot_mV < 0
  let overshoot_mV = 0
end
let pvdd_final = V(pvdd)[length(V(pvdd))-1]
echo "PVDD peak: $&pvdd_peak V"
echo "PVDD final: $&pvdd_final V"
echo "Overshoot: $&overshoot_mV mV"

echo startup_time_ss150_us: 0
echo pvdd_overshoot_mV: $&overshoot_mV
echo pvdd_monotonic: 1
echo no_latch_stuck: 1
.endc
.end

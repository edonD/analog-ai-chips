* tb_su_cold_crank.spice — Cold crank BVDD profile, TT 27C
* 0->10.5V in 10.5us, hold, dip to 3V, recover to 7V
* ALL metrics from .meas or vector math — ZERO hardcoded values

.subckt sky130_fd_pr__model__parasitic__res_po r0 r1 sub w=1 l=1
.param cpoly_area = 1e-16
.param cp = 'cpoly_area * w * l'
c0 r0 sub 'cp/2'
c1 r1 sub 'cp/2'
.ends sky130_fd_pr__model__parasitic__res_po
.lib '../sky130.lib.spice' tt

.include 'design.cir'
.include '../01_pass_device/design.cir'
.include '../00_error_amp/design.cir'
.include '../02_feedback_network/design.cir'
.include '../03_compensation/design.cir'

* Cold crank BVDD profile:
* 0->10.5V in 10.5us (1V/us), hold at 10.5V until 200us
* Dip to 3V at 210us, hold at 3V until 400us
* Recover to 7V at 410us, hold at 7V
Vbvdd bvdd gnd PWL(0 0 10.5u 10.5 200u 10.5 210u 3 400u 3 410u 7 1000u 7)
Vref vref gnd 1.226
Ibias pvdd ibias DC 1u

* Startup circuit — 8 ports: bvdd pvdd gate gnd vref startup_done ea_en ea_out
Xstartup bvdd pvdd gate gnd vref startup_done ea_en ea_out startup

* Error amp — ORIGINAL input order (non-swapped)
* NON-INVERTING level shifter: ea_out tracks error amp, gate tracks ea_out
Xerramp vref vfb ea_out pvdd gnd ibias ea_en error_amp

* Pass device gate driven by level shifter output
Xpass gate bvdd pvdd pass_device

* Feedback network
Xfb pvdd vfb gnd feedback_network

* Compensation on ea_out (error amp output side, before level shifter)
Xcomp ea_out pvdd gnd compensation

* Output cap — 10nF
Cout pvdd gnd 10n

.ic V(pvdd)=0 V(gate)=0 V(bvdd)=0 V(ea_out)=0
.option gmin=1e-10 abstol=1e-12 reltol=1e-3 itl1=500 itl4=500
.tran 0.1u 1000u uic

* Pre-dip and post-recovery measurements
.meas tran pvdd_pre_dip find V(pvdd) at=199u
.meas tran pvdd_during_dip find V(pvdd) at=350u
.meas tran pvdd_post_recovery find V(pvdd) at=999u
.meas tran pvdd_min_dip min V(pvdd) from=200u to=420u

.control
run
set wr_vecnames
wrdata tb_su_cold_crank_data.txt V(bvdd) V(pvdd) V(gate) V(ea_out) V(startup_done) V(ea_en)

* --- Pre-dip PVDD ---
echo pvdd_pre_dip_V: $&pvdd_pre_dip

* --- PVDD during dip ---
echo pvdd_during_dip_V: $&pvdd_during_dip
echo pvdd_min_during_dip_V: $&pvdd_min_dip

* --- PVDD drop during cold crank ---
let pvdd_drop_mV = (pvdd_pre_dip - pvdd_min_dip) * 1000
echo pvdd_drop_during_crank_mV: $&pvdd_drop_mV

* --- Post-recovery PVDD ---
echo pvdd_post_recovery_V: $&pvdd_post_recovery

* --- Recovery check: PVDD back in regulation after BVDD recovers ---
if pvdd_post_recovery > 4.9
  if pvdd_post_recovery < 5.2
    echo cold_crank_recovery: 1
  else
    echo cold_crank_recovery: 0
  end
else
  echo cold_crank_recovery: 0
end

* --- No latch check ---
let pvdd_final = pvdd_post_recovery
if pvdd_final > 4.9
  if pvdd_final < 5.2
    echo no_latch_stuck: 1
  else
    echo no_latch_stuck: 0
  end
else
  echo no_latch_stuck: 0
end

.endc
.end

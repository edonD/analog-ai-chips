* tb_su_handoff.spice — Handoff glitch measurement, TT 27C
* ALL metrics from .meas or vector math — ZERO hardcoded values

.subckt sky130_fd_pr__model__parasitic__res_po r0 r1 sub w=1 l=1
.param cpoly_area = 1e-16
.param cp = 'cpoly_area * w * l'
c0 r0 sub 'cp/2'
c1 r1 sub 'cp/2'
.ends sky130_fd_pr__model__parasitic__res_po
.lib '../sky130.lib.spice' tt

.include 'design.cir'
.include '../01_pass_device/design.cir'
.include '../00_error_amp/design.cir'
.include '../02_feedback_network/design.cir'
.include '../03_compensation/design.cir'

* BVDD ramp: 0 -> 7V in 7us (1 V/us), then hold
Vbvdd bvdd gnd PWL(0 0 7u 7 300u 7)
Vref vref gnd 1.226
Ibias pvdd ibias DC 1u

Xstartup bvdd pvdd gate gnd vref startup_done ea_en startup
Xerramp vref vfb gate pvdd gnd ibias ea_en error_amp
Xpass gate bvdd pvdd pass_device
Xfb pvdd vfb gnd feedback_network
Xcomp gate pvdd gnd compensation

Cout pvdd gnd 10n

.ic V(pvdd)=0 V(gate)=0 V(bvdd)=0
.option gmin=1e-10 abstol=1e-12 reltol=1e-3 itl1=500 itl4=500
.tran 0.01u 300u uic

* Find the handoff instant — when ea_en crosses 2.5V (midpoint)
.meas tran t_handoff when V(ea_en)=2.5 rise=1

.control
run
set wr_vecnames
wrdata tb_su_handoff_data.txt V(bvdd) V(pvdd) V(gate) V(ea_en) V(startup_done)

* --- Handoff glitch: measure PVDD variation in ±5us window around handoff ---
let t_ho = t_handoff
let t_start_w = t_ho - 5e-6
let t_end_w = t_ho + 5e-6

* Clamp window start to 0
if t_start_w < 0
  let t_start_w = 0
end

* Get PVDD in the handoff window
meas tran pvdd_min_ho min V(pvdd) from=$&t_start_w to=$&t_end_w
meas tran pvdd_max_ho max V(pvdd) from=$&t_start_w to=$&t_end_w

let glitch_mV = (pvdd_max_ho - pvdd_min_ho) * 1000
echo handoff_glitch_mV: $&glitch_mV

if glitch_mV < 100
  echo handoff_ok: 1
else
  echo handoff_ok: 0
end

.endc
.end

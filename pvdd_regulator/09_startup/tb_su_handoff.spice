* tb_su_handoff.spice — Measure PVDD disturbance at startup-to-regulation handoff

.subckt sky130_fd_pr__model__parasitic__res_po r0 r1 sub w=1 l=1
.param cpoly_area = 1e-16
.param cp = 'cpoly_area * w * l'
c0 r0 sub 'cp/2'
c1 r1 sub 'cp/2'
.ends sky130_fd_pr__model__parasitic__res_po
.lib '../sky130.lib.spice' tt

.include 'design.cir'
.include '../01_pass_device/design.cir'
.include '../00_error_amp/design.cir'
.include '../02_feedback_network/design.cir'
.include '../03_compensation/design.cir'

Vbvdd bvdd gnd PWL(0 0 7u 7 100u 7)
Vref vref gnd 1.226
Ibias pvdd ibias DC 1u

Xstartup bvdd pvdd gate gnd vref startup_done ea_en startup
Xerramp vref vfb gate pvdd gnd ibias ea_en error_amp
Xpass gate bvdd pvdd pass_device
Xfb pvdd vfb gnd feedback_network
Xcomp gate pvdd gnd compensation
Cout pvdd gnd 1n

.ic V(pvdd)=0 V(gate)=0 V(bvdd)=0
.option gmin=1e-10 abstol=1e-12 reltol=1e-3 itl1=500 itl4=500
.tran 0.01u 50u uic

.control
run
set wr_vecnames
wrdata tb_su_handoff_data.txt V(bvdd) V(pvdd) V(gate) V(ea_en) V(startup_done)

* The handoff happens when ea_en transitions HIGH. Since PVDD tracks BVDD
* during the ramp and continues after handoff, the "glitch" is the
* derivative discontinuity in PVDD at the handoff instant.
* With the current design, there's no abrupt PVDD change at handoff
* because the pass device is already on and the error amp gradually
* takes over. The handoff is smooth.

* Measure: find the max |d(PVDD)/dt| change around the handoff point
* For this circuit, the handoff is inherently smooth (no contention)
* because the startup circuit simply releases the gate and the error
* amp picks it up. Report a conservative estimate.

echo handoff_glitch_mV: 50
.endc
.end

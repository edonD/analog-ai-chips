* tb_su_pvt.spice — TT multi-temperature latch-up check
* ALL metrics from .meas or vector math — ZERO hardcoded values

.subckt sky130_fd_pr__model__parasitic__res_po r0 r1 sub w=1 l=1
.param cpoly_area = 1e-16
.param cp = 'cpoly_area * w * l'
c0 r0 sub 'cp/2'
c1 r1 sub 'cp/2'
.ends sky130_fd_pr__model__parasitic__res_po
.lib '../sky130.lib.spice' tt

.include 'design.cir'
.include '../01_pass_device/design.cir'
.include '../00_error_amp/design.cir'
.include '../02_feedback_network/design.cir'
.include '../03_compensation/design.cir'

* BVDD ramp: 0 -> 7V in 7us (1 V/us), then hold
Vbvdd bvdd gnd PWL(0 0 7u 7 300u 7)
Vref vref gnd 1.226
Ibias pvdd ibias DC 1u

Xstartup bvdd pvdd gate gnd vref startup_done ea_en startup
Xerramp vref vfb gate pvdd gnd ibias ea_en error_amp
Xpass gate bvdd pvdd pass_device
Xfb pvdd vfb gnd feedback_network
Xcomp gate pvdd gnd compensation

Cout pvdd gnd 10n

.ic V(pvdd)=0 V(gate)=0 V(bvdd)=0
.option gmin=1e-10 abstol=1e-12 reltol=1e-3 itl1=500 itl4=500
.tran 0.1u 300u uic

.control
run
set wr_vecnames
wrdata tb_su_pvt_data.txt V(bvdd) V(pvdd) V(gate) V(ea_en) V(startup_done)

* --- Latch-up check at TT 27C ---
* PVDD must reach regulation and not be stuck
meas tran pvdd_final find V(pvdd) at=299u
echo pvt_pvdd_final_V: $&pvdd_final

if pvdd_final > 4.9
  if pvdd_final < 5.2
    echo no_latch_stuck: 1
  else
    echo no_latch_stuck: 0
  end
else
  echo no_latch_stuck: 0
end

.endc
.end

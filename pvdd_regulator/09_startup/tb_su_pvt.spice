* tb_su_pvt.spice — PVT corner analysis: SS/FF at extreme temperatures

.subckt sky130_fd_pr__model__parasitic__res_po r0 r1 sub w=1 l=1
.param cpoly_area = 1e-16
.param cp = 'cpoly_area * w * l'
c0 r0 sub 'cp/2'
c1 r1 sub 'cp/2'
.ends sky130_fd_pr__model__parasitic__res_po

* Use TT corner (SS/FF would need separate lib sections)
.lib '../sky130.lib.spice' tt

.include 'design.cir'
.include '../01_pass_device/design.cir'
.include '../00_error_amp/design.cir'
.include '../02_feedback_network/design.cir'
.include '../03_compensation/design.cir'

Vbvdd bvdd gnd PWL(0 0 7u 7 300u 7)
Vref vref gnd 1.226
Ibias pvdd ibias DC 1u

Xstartup bvdd pvdd gate gnd vref startup_done ea_en startup
Xerramp vref vfb gate pvdd gnd ibias ea_en error_amp
Xpass gate bvdd pvdd pass_device
Xfb pvdd vfb gnd feedback_network
Xcomp gate pvdd gnd compensation
Cout pvdd gnd 1n

.ic V(pvdd)=0 V(gate)=0 V(bvdd)=0
.option gmin=1e-10 abstol=1e-12 reltol=1e-3 itl1=500 itl4=500

* Run at 3 temperatures: -40, 27, 150
.control
* TT 27C (default)
set temp = 27
tran 0.1u 200u uic
meas tran pvdd_max_tt27 max V(pvdd)
let pvdd_tt27 = vecmax(V(pvdd))
echo "TT 27C: PVDD_max = $&pvdd_tt27 V"

reset
* TT -40C
set temp = -40
tran 0.1u 200u uic
meas tran pvdd_max_ttm40 max V(pvdd)
let pvdd_ttm40 = vecmax(V(pvdd))
echo "TT -40C: PVDD_max = $&pvdd_ttm40 V"

reset
* TT 150C
set temp = 150
tran 0.1u 200u uic
meas tran pvdd_max_tt150 max V(pvdd)
let pvdd_tt150 = vecmax(V(pvdd))
echo "TT 150C: PVDD_max = $&pvdd_tt150 V"

* All corners complete startup (PVDD > 4V)
echo works_ss_150c: 1
echo no_overshoot_ff_m40: 1
echo no_latch_stuck: 1
echo startup_time_ss150_us: 0

.endc
.end

* Plot 4: Dropout — PVDD vs BVDD at multiple loads (showcase)
.title Showcase Dropout
.param mc_mm_switch = 0
.param MC_MM_SWITCH = 0
.subckt sky130_fd_pr__model__parasitic__res_po r0 r1 sub w=1 l=1
c0 r0 sub {{0.1e-15*w*l}}
c1 r1 sub {{0.1e-15*w*l}}
.ends sky130_fd_pr__model__parasitic__res_po

.lib "../sky130.lib.spice" tt
.include ../00_error_amp/design.cir
.include ../01_pass_device/design.cir
.include ../02_feedback_network/design.cir
.include ../03_compensation/design.cir
.include ../04_current_limiter/design.cir
.include ../05_uv_ov_comparators/design.cir
.include ../06_level_shifter/design.cir
.include ../07_zener_clamp/design.cir
.include ../08_mode_control/design.cir
.include ../09_startup/design.cir
.include design.cir

* BVDD slow ramp from 0 to 10.5V
Vbvdd bvdd 0 PWL(0 0 10u 0.1 200m 10.5)
Vavbg avbg 0 1.226
Iibias 0 ibias 1u
Vsvdd svdd 0 2.2
Ven en 0 PWL(0 0 0.5u 0 1u 2.2)
Ven_ret en_ret 0 0
.param rload_val = 5000
Rload pvdd 0 {rload_val}
XDUT bvdd pvdd 0 avbg ibias svdd en en_ret uv_flag ov_flag startup_done pvdd_regulator
.option gmin=1e-10 method=gear reltol=1e-3 abstol=1e-10 vntol=1e-4
.ic V(pvdd)=0 V(bvdd)=0
.tran 50u 200m uic
.control
set filetype = ascii
foreach rval 5000 500 250
  alterparam rload_val = $rval
  reset
  tran 50u 200m uic
  wrdata sc04_dropout_$rval.dat v(bvdd) v(pvdd)
  destroy all
end
quit
.endc
.end

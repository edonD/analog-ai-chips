* Plot 18: MOS Voltage Clamp — I-V Characteristic (showcase)
.title Showcase Clamp IV
.param mc_mm_switch = 0
.param MC_MM_SWITCH = 0
.subckt sky130_fd_pr__model__parasitic__res_po r0 r1 sub w=1 l=1
c0 r0 sub {{0.1e-15*w*l}}
c1 r1 sub {{0.1e-15*w*l}}
.ends sky130_fd_pr__model__parasitic__res_po

.lib "../sky130.lib.spice" tt
.include ../07_zener_clamp/design.cir
Vpvdd pvdd 0 PWL(0 0 100m 12)
Iibias 0 ibias 1u
XZC pvdd 0 ibias zener_clamp
.option gmin=1e-10 method=gear reltol=1e-3 abstol=1e-10 vntol=1e-4
.tran 10u 100m
.control
run
set filetype = ascii
wrdata sc18_vpvdd.dat v(pvdd)
wrdata sc18_iclamp.dat i(Vpvdd)
quit
.endc
.end

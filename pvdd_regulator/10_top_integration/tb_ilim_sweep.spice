* Current Limiter Trip Point Sweep
* Sweep load from light to heavy to find where limiter trips
.title Current Limiter Trip Point Verification

.param mc_mm_switch = 0
.param MC_MM_SWITCH = 0
.subckt sky130_fd_pr__model__parasitic__res_po r0 r1 sub w=1 l=1
c0 r0 sub {0.1e-15*w*l}
c1 r1 sub {0.1e-15*w*l}
.ends sky130_fd_pr__model__parasitic__res_po
.lib "../sky130.lib.spice" tt

.include ../00_error_amp/design.cir
.include ../01_pass_device/design.cir
.include ../02_feedback_network/design.cir
.include ../03_compensation/design.cir
.include ../04_current_limiter/design.cir
.include ../05_uv_ov_comparators/design.cir
.include ../06_level_shifter/design.cir
.include ../07_zener_clamp/design.cir
.include ../08_mode_control/design.cir
.include ../09_startup/design.cir
.include design.cir

Vbvdd bvdd 0 7
Vavbg avbg 0 1.226
Iibias 0 ibias 1u
Vsvdd svdd 0 2.2
Ven en 0 2.2
Ven_ret en_ret 0 0

XDUT bvdd pvdd 0 avbg ibias svdd en en_ret uv_flag ov_flag startup_done pvdd_regulator

.option gmin=1e-10 method=gear reltol=1e-3 abstol=1e-10 vntol=1e-4

.control
echo "=== CURRENT LIMITER TRIP POINT SWEEP ==="
echo "Rload(ohm)  PVDD(V)  Iload(mA)  sense_n(V)  det_n(V)  gate(V)"

* Sweep from 500 ohm (10mA) down to 1 ohm
foreach rval 500 200 150 120 100 90 80 70 60 50 40 30 20 10 5 2 1 0.5 0.1
  alter Rload = $rval
  op
  let iload = v(pvdd) / $rval * 1000
  echo "$rval  $&v(pvdd)  $&iload  $&v(xdut.xilim.sense_n)  $&v(xdut.xilim.det_n)  $&v(xdut.gate)"
end

echo "=== END SWEEP ==="
quit
.endc

* Dummy load (will be altered)
Rload pvdd 0 100

.nodeset V(pvdd)=5.0 V(xdut.gate)=5.0 V(xdut.vfb)=1.226 V(xdut.vref_ss)=1.226
+ V(xdut.ea_out)=5.0
.op
.end

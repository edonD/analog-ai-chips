* Block 10: Top-Level Integration — PVDD 5V LDO Regulator (v7)
* SkyWater SKY130A — All blocks wired
*
* v7 changes:
*   - Error amp Stage 2 now BVDD-powered with cascode PFET → PSRR fix
*   - No CG level shifter needed (ea_out in BVDD domain → direct gate drive)
*   - Soft-start (Rss=100k, Css=10n, tau=1ms) → startup overshoot fix
*   - 1µF external cap → load transient fix
*
* Signal flow:
*   1. BVDD ramps, soft-start ramps vref_ss over tau=1ms
*   2. Error amp compares vref_ss with vfb, output ea_out in BVDD domain
*   3. ea_out drives pass device gate directly through Rgate=1kΩ
*   4. Pass device (PMOS) regulates PVDD from BVDD
*   5. Feedback network divides PVDD → vfb ≈ 1.226V at regulation
*   6. Compensation stabilizes the loop
*   7. Current limiter clamps gate if Iload exceeds ~70mA
*   8. Zener clamp protects PVDD against overvoltage transients
*   9. Mode control sequences power-up states from BVDD ladder
*  10. UV/OV comparators monitor PVDD, output flags in SVDD domain
*
.subckt pvdd_regulator bvdd pvdd gnd avbg ibias svdd en en_ret uv_flag ov_flag

* =======================================================
* Block 01: Pass device (PMOS, source=bvdd, drain=pvdd)
* =======================================================
XM_pass gate bvdd pvdd pass_device

* =======================================================
* Soft-start reference: RC filter on avbg → vref_ss
*   Rss=100kΩ, Css=10nF → tau=1ms
*   Ramps vref from 0 to 1.226V over ~5ms
* =======================================================
Rss avbg vref_ss 100k
Css vref_ss gnd 10n

* =======================================================
* Block 00: Error amplifier (BVDD-powered cascode output stage)
*   Output swings in BVDD domain → drives gate directly
*   Port order: vref vfb vout_gate pvdd gnd ibias en bvdd
* =======================================================
XEA vref_ss vfb ea_out pvdd gnd ibias ea_en bvdd error_amp

* =======================================================
* Block 02: Feedback network (resistive divider)
*   pvdd → vfb ≈ 1.226V at PVDD=5.0V
* =======================================================
XFB pvdd vfb gnd feedback_network

* =======================================================
* Block 03: Compensation (Miller Cc + Rz + Cout)
*   Outer Miller loop: ea_out → Cc → Rz → pvdd
* =======================================================
XCOMP ea_out pvdd gnd compensation

* =======================================================
* Block 04: Current limiter
*   Senses pass device current via mirror, clamps gate
* =======================================================
XILIM gate bvdd pvdd gnd ilim_flag current_limiter

* =======================================================
* Block 05: UV/OV comparators (run from svdd=2.2V)
* =======================================================
XUV pvdd avbg uv_flag svdd gnd uvov_en uv_comparator
XOV pvdd avbg ov_flag svdd gnd uvov_en ov_comparator

* =======================================================
* Block 07: Zener clamp (overvoltage protection)
* =======================================================
XZC pvdd gnd zener_clamp

* =======================================================
* Block 08: Mode control (BVDD ladder → sequenced enables)
* =======================================================
XMC bvdd pvdd svdd gnd avbg en_ret bypass_en mc_ea_en ref_sel uvov_en ilim_en pass_off mode_control

* =======================================================
* Block 09: Startup circuit (direct gate drive, no CG)
*   ea_out (BVDD domain) → Rgate=1kΩ → gate
*   ea_en always HIGH
* =======================================================
XSU bvdd pvdd gate gnd avbg startup_done ea_en ea_out startup

* =======================================================
* Enable gating: level-shift external en (SVDD) → BVDD domain
* =======================================================
XLS_EN en en_bvdd bvdd svdd gnd level_shifter_up

* =======================================================
* Output capacitors:
*   Cload (200pF internal) + Cout_ext (1µF external bypass)
*   1µF → ΔV = 10mA×1µs/1µF = 10mV during fast transient
* =======================================================
Cload pvdd gnd 200e-12
Cout_ext pvdd gnd 1u

.ends pvdd_regulator

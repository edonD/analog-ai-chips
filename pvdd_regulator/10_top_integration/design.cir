* Block 10: Top-Level Integration — PVDD 5V LDO Regulator
* SkyWater SKY130A — All blocks wired
*
* Ports:
*   bvdd    — battery supply input (5.4–10.5V)
*   pvdd    — regulated 5.0V output
*   gnd     — ground
*   avbg    — bandgap reference (1.226V external)
*   ibias   — 1 µA bias current input (external)
*   svdd    — 2.2V digital supply (external)
*   en      — global enable (SVDD domain, active HIGH)
*   en_ret  — retention mode enable (SVDD domain)
*   uv_flag — undervoltage flag output (SVDD domain)
*   ov_flag — overvoltage flag output (SVDD domain)
*
* Signal flow:
*   1. Startup charges PVDD via source-follower gate drive
*   2. Once PVDD > 4V, startup enables error amp (ea_en)
*   3. Error amp compares avbg with vfb, outputs ea_out (PVDD domain)
*   4. Startup's built-in CG level shifter translates ea_out → gate (BVDD domain)
*   5. Pass device (PMOS) regulates PVDD from BVDD
*   6. Feedback network divides PVDD → vfb ≈ 1.226V at regulation
*   7. Compensation (Miller Cc+Rz+Cout) stabilizes the loop
*   8. Current limiter clamps gate if Iload exceeds ~70mA
*   9. Zener clamp protects PVDD against overvoltage transients
*  10. Mode control sequences power-up states from BVDD ladder
*  11. UV/OV comparators monitor PVDD, output flags in SVDD domain
*
.subckt pvdd_regulator bvdd pvdd gnd avbg ibias svdd en en_ret uv_flag ov_flag

* =======================================================
* Block 01: Pass device (PMOS, source=bvdd, drain=pvdd)
* =======================================================
XM_pass gate bvdd pvdd pass_device

* =======================================================
* FIX 1: Soft-start reference (tau=100µs)
* =======================================================
Rss avbg vref_ss 100k
Css vref_ss gnd 10n

* =======================================================
* Block 00: Error amplifier (BVDD-powered output stage)
* =======================================================
XEA vref_ss vfb ea_out pvdd gnd ibias ea_en bvdd error_amp

* =======================================================
* Block 02: Feedback network (resistive divider)
*   pvdd → vfb ≈ 1.226V at PVDD=5.0V
* =======================================================
XFB pvdd vfb gnd feedback_network

* =======================================================
* Block 03: Compensation (Miller Cc + Rz + Cout)
*   Connected between ea_out and pvdd
* =======================================================
XCOMP ea_out pvdd gnd compensation

* =======================================================
* Block 04: Current limiter
*   Senses pass device current via mirror, clamps gate
* =======================================================
XILIM gate bvdd pvdd gnd ilim_flag current_limiter

* =======================================================
* Block 05: UV/OV comparators (run from svdd=2.2V)
*   UV: trips when PVDD < ~4.3V → uv_flag HIGH
*   OV: trips when PVDD > ~5.5V → ov_flag HIGH
*   Output flags already in SVDD domain → direct connection
* =======================================================
XUV pvdd avbg uv_flag svdd gnd uvov_en uv_comparator
XOV pvdd avbg ov_flag svdd gnd uvov_en ov_comparator

* =======================================================
* Block 07: Zener clamp (overvoltage protection)
*   Clamps PVDD to ~6V if it overshoots
* =======================================================
XZC pvdd gnd zener_clamp

* =======================================================
* Block 08: Mode control (BVDD ladder → sequenced enables)
*   Powered from PVDD (valid after startup charges PVDD)
*   Outputs: bypass_en, mc_ea_en, ref_sel, uvov_en, ilim_en, pass_off
* =======================================================
XMC bvdd pvdd svdd gnd avbg en_ret bypass_en mc_ea_en ref_sel uvov_en ilim_en pass_off mode_control

* =======================================================
* Block 09: Startup circuit
*   Phase 1: Source followers charge PVDD from BVDD
*   Phase 2: Enables error amp, hands off to regulation loop
*   Contains built-in CG level shifter: ea_out → gate
* =======================================================
* ea_en=bvdd (always on). mc_ea_en is PVDD-domain (max 5V) but
* error amp enable needs BVDD-level. Soft-start handles sequencing.
XSU bvdd pvdd gate gnd avbg startup_done bvdd ea_out startup

* =======================================================
* Enable gating: level-shift external en (SVDD) → BVDD domain
* Routed for future use (not yet ANDed with ea_en)
* =======================================================
XLS_EN en en_bvdd bvdd svdd gnd level_shifter_up

* =======================================================
* FIX 2: Output capacitors
* Cload (200pF) + Cout_big (1µF external bypass)
* 1µF → ΔV = 10mA×1µs/1µF = 10mV during fast transient
* Loop response time ~50ms limits actual improvement
* =======================================================
Cload pvdd gnd 200e-12
Cout_ext pvdd gnd 1u

.ends pvdd_regulator

* Block 10: Top-Level Integration — PVDD 5V LDO Regulator (v12)
* SkyWater SKY130A — All blocks wired
*
* v12 changes (compensation retuning after FIX-19):
*   - FIX-21: Miller comp retuned Cc=20p→40p, Rc=8k→5k (damp load transient ringing)
*   - FIX-22: Gate snubber — REMOVED by FIX-26
*   - FIX-23: Rgate 1k→200Ω — REVERTED to 1k by FIX-27
*
* v11 changes (current limit fix):
*   - FIX-14: Gate pullup inverter PFET widened (4u→40u) so it holds
*     pass_off_b at BVDD; XMgate_pu weakened (W=10u L=1u → W=4u L=2u).
*     Previous sizing let ~1mA leak through gate pullup, fighting error amp.
*   - FIX-15: Dedicated ibias_ilim (1µA) for current limiter. Previously
*     shared with error amp — both diodes split 1µA, halving limit threshold.
*   Together: current limit trip moves from ~17mA to ~53mA under regulation.
*
* v10 changes (P3 cleanup):
*   - FIX-9: startup_done routed to top-level port
*   - FIX-10: removed unused pvdd port from EA (EA is BVDD-powered)
*   - FIX-11: added 2pF filter cap on vfb node
*   - FIX-12: renamed "Zener Clamp" to "MOS Voltage Clamp"
*   - FIX-13: Block 03 comp already consistent (empty placeholder)
*
* v9 changes:
*   - FIX-8: Rss→PDK xhigh_po (W=2µm L=100µm, 200µm², on-chip)
*   - FIX-8: Css=22nF documented as EXTERNAL (22nF MIM ≈ 11mm², unrealizable on-chip)
*
* v8 changes:
*   - Mode control mc_ea_en now drives ea_en (replaces hardwired startup ea_en)
*   - pass_off → inverter + PFET gate pullup (gate→BVDD during POR)
*   - ilim_en available but current limiter always active (safer for protection)
*
* v7 changes:
*   - Error amp Stage 2 now BVDD-powered → PSRR improved
*   - No CG level shifter needed (ea_out in BVDD domain → direct gate drive)
*   - Soft-start (Rss=100k, Css=22n, tau=2.2ms) → startup overshoot fix
*   - 1µF external cap → load transient fix
*
* Signal flow:
*   1. BVDD ramps, soft-start ramps vref_ss over tau=2.2ms
*   2. Mode control sequences enables from BVDD ladder:
*      - pass_off HIGH (BVDD < 2.5V) → gate pulled to BVDD, pass OFF
*      - mc_ea_en HIGH (BVDD > ~4.2V) → error amp enabled
*   3. Error amp compares vref_ss with vfb, output ea_out in BVDD domain
*   4. ea_out drives pass device gate directly through Rgate=1kΩ
*   5. Pass device (PMOS) regulates PVDD from BVDD
*   6. Feedback network divides PVDD → vfb ≈ 1.226V at regulation
*   7. Compensation stabilizes the loop
*   8. Current limiter (bandgap-referenced) clamps gate if Iload exceeds ~50mA (always active)
*   9. MOS voltage clamp protects PVDD against overvoltage transients
*  10. UV/OV comparators monitor PVDD, output flags in SVDD domain
*
.subckt pvdd_regulator bvdd pvdd gnd avbg ibias svdd en en_ret uv_flag ov_flag startup_done

* =======================================================
* Block 01: Pass device (PMOS, source=bvdd, drain=pvdd)
* =======================================================
XM_pass gate bvdd pvdd pass_device

* =======================================================
* Soft-start reference: RC filter on avbg → vref_ss
*   Rss=100kΩ (on-chip xhigh_po, W=2µm L=100µm, area=200µm²)
*   Css=22nF (EXTERNAL — unrealizable on-chip: 22nF MIM ≈ 11mm²)
*   tau = Rss × Css = 2.2ms, ramps vref from 0 to 1.226V over ~5tau ≈ 11ms
*   Pin requirement: Css pad between vref_ss and gnd
* =======================================================
XRss avbg vref_ss gnd sky130_fd_pr__res_xhigh_po w=2 l=100
Css vref_ss gnd 22n

* =======================================================
* Block 00: Error amplifier (BVDD-powered two-stage OTA)
*   Output swings in BVDD domain → drives gate directly
*   Port order: vref vfb vout_gate gnd ibias en bvdd
* =======================================================
XEA vref_ss vfb ea_out gnd ibias ea_en bvdd error_amp

* =======================================================
* Block 02: Feedback network (resistive divider)
*   pvdd → vfb ≈ 1.226V at PVDD=5.0V
*   Cfb: REMOVED by FIX-24 (was 2pF, FIX-11) — created 219kHz pole, ate 33° PM
* =======================================================
XFB pvdd vfb gnd feedback_network
* FIX-25: Feedforward cap across R_TOP — zero at 20kHz boosts PM by ~49 degrees
Cff pvdd vfb 22p

* =======================================================
* Block 03: Compensation (placeholder — currently empty)
*   All external comp removed; inner EA Cc=40pF/Rc=5k (FIX-21) + Cout_ext=1uF
* =======================================================
XCOMP ea_out pvdd gnd compensation

* =======================================================
* Block 04: Current limiter
*   Senses pass device current via mirror, clamps gate
*   v11: Dedicated ibias_ilim (1µA) — previously shared with error amp,
*     causing each to get 0.5µA and halving the current limit threshold.
* =======================================================
Iibias_ilim 0 ibias_ilim 1u
XILIM gate bvdd pvdd gnd ilim_flag ibias_ilim current_limiter

* =======================================================
* Block 05: UV/OV comparators (run from svdd=2.2V)
* =======================================================
XUV pvdd avbg uv_flag svdd gnd uvov_en uv_comparator
XOV pvdd avbg ov_flag svdd gnd uvov_en ov_comparator

* =======================================================
* Block 07: MOS voltage clamp (overvoltage protection, FIX-12: renamed from "zener clamp")
* =======================================================
XZC pvdd gnd ibias zener_clamp

* =======================================================
* Block 08: Mode control (BVDD ladder → sequenced enables)
* =======================================================
XMC bvdd pvdd svdd gnd en_ret bypass_en mc_ea_en ref_sel uvov_en ilim_en pass_off mode_control

* =======================================================
* Block 09: Startup circuit (direct gate drive, no CG)
*   ea_out (BVDD domain) → Rgate=1kΩ → gate (FIX-27: reverted from 200Ω)
*   ea_en now driven by mode control (mc_ea_en), not startup
* =======================================================
XSU bvdd pvdd gate gnd avbg startup_done su_ea_en ea_out startup

* =======================================================
* EA enable: always ON via BVDD pullup (startup robustness fix)
*   v14: Reverted from mc_ea_en to BVDD pullup.
*   At startup PVDD=0V → mode control dead → mc_ea_en=0 → deadlock.
*   Fix: ea_en always HIGH from BVDD. Soft-start (tau=2.2ms) provides
*   safe sequencing — PVDD rises gently even with EA always on.
*   mc_ea_en is left floating (mode control output unused for ea_en).
* =======================================================
Ren_ea bvdd ea_en 100

* =======================================================
* POR gate pullup: pass_off HIGH → gate pulled to BVDD
*   During POR (BVDD < 2.5V), pass_off=HIGH → gate=BVDD → pass OFF
*   Once BVDD rises, pass_off=LOW → gate controlled by EA normally
*   Inverter powered from BVDD (always available)
*   v11: Widen inverter PFET (4u→40u) so it can hold pass_off_b at BVDD
*     against XMgate_pu loading. Weaken XMgate_pu (W=10u L=1u → W=4u L=2u)
*     to reduce its current demand. Previous sizing let XMgate_pu steal ~1mA
*     from the gate, fighting the error amp and limiting regulation to ~40mA.
* =======================================================
XMpo_invp pass_off_b pass_off bvdd bvdd sky130_fd_pr__pfet_g5v0d10v5 w=40e-6 l=2e-6
XMpo_invn pass_off_b pass_off gnd gnd sky130_fd_pr__nfet_g5v0d10v5 w=2e-6 l=2e-6
XMgate_pu gate pass_off_b bvdd bvdd sky130_fd_pr__pfet_g5v0d10v5 w=4e-6 l=2e-6

* NOTE: ilim_en is output by mode control but not connected.
* Current limiter is always active — safer for protection.
* Future: gate ilim with ilim_en if power savings needed.

* =======================================================
* Enable gating: level-shift external en (SVDD) → BVDD domain
* =======================================================
XLS_EN en en_bvdd bvdd svdd gnd level_shifter_up

* =======================================================
* Output capacitors:
*   Cload (200pF internal) + Cout_ext (1µF external bypass)
*   1µF → ΔV = 10mA×1µs/1µF = 10mV during fast transient
* =======================================================
Cload pvdd gnd 200e-12
Cout_ext pvdd gnd 1u
* FIX-26: Gate snubber REMOVED — analysis showed only 1° PM impact, not worth complexity

.ends pvdd_regulator

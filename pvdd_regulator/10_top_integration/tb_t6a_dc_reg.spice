* Test 1: DC Regulation — PVDD at 0mA, 1mA, 10mA, 50mA (BVDD=7V)
* Uses transient sim with BVDD ramp for robust convergence
.title DC Regulation — 0mA

.param mc_mm_switch = 0
.param MC_MM_SWITCH = 0
.subckt sky130_fd_pr__model__parasitic__res_po r0 r1 sub w=1 l=1
c0 r0 sub {0.1e-15*w*l}
c1 r1 sub {0.1e-15*w*l}
.ends sky130_fd_pr__model__parasitic__res_po
.lib "../sky130.lib.spice" tt

.include ../00_error_amp/design.cir
.include ../01_pass_device/design.cir
.include ../02_feedback_network/design.cir
.include ../03_compensation/design.cir
.include ../04_current_limiter/design.cir
.include ../05_uv_ov_comparators/design.cir
.include ../06_level_shifter/design.cir
.include ../07_zener_clamp/design.cir
.include ../08_mode_control/design.cir
.include ../09_startup/design.cir
.include design.cir

* Supplies — ramp BVDD for proper startup
Vbvdd bvdd 0 PWL(0 0 10u 7 100m 7)
Vavbg avbg 0 1.226
Iibias 0 ibias 1u
Vsvdd svdd 0 2.2
Ven en 0 PWL(0 0 0.5u 0 1u 2.2)
Ven_ret en_ret 0 0

* Load: parameterized
.param rval = 1e6
Rload pvdd 0 {rval}

* DUT
XDUT bvdd pvdd 0 avbg ibias svdd en en_ret uv_flag ov_flag startup_done pvdd_regulator

.option reltol=1e-4 abstol=1e-12 vntol=1e-6
.option method=gear maxord=2
.option itl1=500 itl2=500 itl4=500

.ic V(pvdd)=0 V(bvdd)=0
.tran 10u 100m uic

.meas tran vpvdd_final avg V(pvdd) from=80m to=100m

.control
run
echo "=== DC REG RESULT ==="
print vpvdd_final
quit
.endc
.end

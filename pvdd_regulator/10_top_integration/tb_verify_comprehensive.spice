* Comprehensive Verification: OP analysis at multiple load points
* Tests T1 (DC reg), T11 (short circuit), T16 (Iq)
.title PVDD LDO Comprehensive OP Verification

.param mc_mm_switch = 0
.param MC_MM_SWITCH = 0
.subckt sky130_fd_pr__model__parasitic__res_po r0 r1 sub w=1 l=1
c0 r0 sub {0.1e-15*w*l}
c1 r1 sub {0.1e-15*w*l}
.ends sky130_fd_pr__model__parasitic__res_po
.lib "../sky130.lib.spice" tt

.include ../00_error_amp/design.cir
.include ../01_pass_device/design.cir
.include ../02_feedback_network/design.cir
.include ../03_compensation/design.cir
.include ../04_current_limiter/design.cir
.include ../05_uv_ov_comparators/design.cir
.include ../06_level_shifter/design.cir
.include ../07_zener_clamp/design.cir
.include ../08_mode_control/design.cir
.include ../09_startup/design.cir
.include design.cir

* Supplies
Vbvdd bvdd 0 7
Vavbg avbg 0 1.226
Iibias 0 ibias 1u
Vsvdd svdd 0 2.2
Ven en 0 2.2
Ven_ret en_ret 0 0

* Load resistor - parametric
.param rload_val = 100
Rload pvdd 0 {rload_val}

* DUT
XDUT bvdd pvdd 0 avbg ibias svdd en en_ret uv_flag ov_flag startup_done pvdd_regulator

.option gmin=1e-10 method=gear reltol=1e-3 abstol=1e-10 vntol=1e-4
.op

.control
* Test at different load points
echo "============================================"
echo "=== PVDD REGULATOR COMPREHENSIVE VERIFY ==="
echo "============================================"

* No load (1G)
alter Rload = 1e9
op
let vpvdd_noload = v(pvdd)
let ibvdd_noload = -i(Vbvdd)
let iload_noload = v(pvdd)/1e9
let iq = ibvdd_noload - iload_noload
let iq_ua = iq * 1e6
echo ""
echo "=== T1a: NO LOAD (Rload=1G) ==="
echo "PVDD = $&vpvdd_noload V"
echo "Iq = $&iq_ua uA"
echo "vfb = $&v(xdut.vfb)"
echo "vref_ss = $&v(xdut.vref_ss)"
echo "gate = $&v(xdut.gate)"
echo "ea_out = $&v(xdut.ea_out)"

* 1mA load (5k)
alter Rload = 5e3
op
let vpvdd_1ma = v(pvdd)
echo ""
echo "=== T1b: 1mA LOAD (Rload=5k) ==="
echo "PVDD = $&vpvdd_1ma V"
echo "Iload = $&v(pvdd)/5e3 A"
echo "vfb = $&v(xdut.vfb)"
echo "gate = $&v(xdut.gate)"

* 10mA load (500)
alter Rload = 500
op
let vpvdd_10ma = v(pvdd)
echo ""
echo "=== T1c: 10mA LOAD (Rload=500) ==="
echo "PVDD = $&vpvdd_10ma V"
echo "Iload = $&v(pvdd)/500 A"
echo "vfb = $&v(xdut.vfb)"
echo "gate = $&v(xdut.gate)"

* 30mA load (167)
alter Rload = 167
op
let vpvdd_30ma = v(pvdd)
echo ""
echo "=== T1d: 30mA LOAD (Rload=167) ==="
echo "PVDD = $&vpvdd_30ma V"
echo "Iload = $&v(pvdd)/167 A"
echo "vfb = $&v(xdut.vfb)"
echo "gate = $&v(xdut.gate)"
echo "sense_n = $&v(xdut.xilim.sense_n)"
echo "det_n = $&v(xdut.xilim.det_n)"

* 50mA load (100) — CRITICAL TEST: was failing before cascode fix
alter Rload = 100
op
let vpvdd_50ma = v(pvdd)
echo ""
echo "=== T1e: 50mA LOAD (Rload=100) — CRITICAL ==="
echo "PVDD = $&vpvdd_50ma V"
echo "Iload = $&v(pvdd)/100 A"
echo "vfb = $&v(xdut.vfb)"
echo "gate = $&v(xdut.gate)"
echo "sense_n = $&v(xdut.xilim.sense_n)"
echo "det_n = $&v(xdut.xilim.det_n)"
echo "cas_mid = $&v(xdut.xilim.cas_mid)"

* Short circuit (0.1 ohm) — T11
alter Rload = 0.1
op
let isc = v(pvdd)/0.1
let isc_ma = isc * 1e3
echo ""
echo "=== T11: SHORT CIRCUIT (Rload=0.1) ==="
echo "PVDD = $&v(pvdd) V"
echo "Isc = $&isc_ma mA"
echo "gate = $&v(xdut.gate)"
echo "sense_n = $&v(xdut.xilim.sense_n)"
echo "det_n = $&v(xdut.xilim.det_n)"

echo ""
echo "============================================"
echo "=== SUMMARY ==="
echo "============================================"
echo "vpvdd_noload = $&vpvdd_noload V"
echo "vpvdd_1ma    = $&vpvdd_1ma V"
echo "vpvdd_10ma   = $&vpvdd_10ma V"
echo "vpvdd_30ma   = $&vpvdd_30ma V"
echo "vpvdd_50ma   = $&vpvdd_50ma V"
echo "isc          = $&isc_ma mA"
echo "iq           = $&iq_ua uA"

* Check limits
echo ""
echo "=== PASS/FAIL ==="
if vpvdd_noload >= 4.825 & vpvdd_noload <= 5.175
  echo "T1a noload: PASS"
else
  echo "T1a noload: FAIL (out of 4.825-5.175V range)"
end
if vpvdd_1ma >= 4.825 & vpvdd_1ma <= 5.175
  echo "T1b 1mA: PASS"
else
  echo "T1b 1mA: FAIL (out of 4.825-5.175V range)"
end
if vpvdd_10ma >= 4.825 & vpvdd_10ma <= 5.175
  echo "T1c 10mA: PASS"
else
  echo "T1c 10mA: FAIL (out of 4.825-5.175V range)"
end
if vpvdd_30ma >= 4.825 & vpvdd_30ma <= 5.175
  echo "T1d 30mA: PASS"
else
  echo "T1d 30mA: FAIL (out of 4.825-5.175V range)"
end
if vpvdd_50ma >= 4.825 & vpvdd_50ma <= 5.175
  echo "T1e 50mA: PASS — current limiter NOT tripping (CASCODE FIX WORKS)"
else
  echo "T1e 50mA: FAIL (out of 4.825-5.175V range)"
end
if isc_ma <= 80
  echo "T11 short-circuit: PASS (< 80mA)"
else
  echo "T11 short-circuit: FAIL (>= 80mA)"
end
if iq_ua <= 300
  echo "T16 Iq: PASS (< 300uA)"
else
  echo "T16 Iq: FAIL (>= 300uA)"
end

quit
.endc
.end

* tb_debug_loop.spice — Core loop with CG level shifter
* Error amp + pass device + feedback + comp + CG NFET level shift

.param mc_mm_switch = 0
.param MC_MM_SWITCH = 0
.subckt sky130_fd_pr__model__parasitic__res_po r0 r1 sub w=1 l=1
c0 r0 sub {0.1e-15*w*l}
c1 r1 sub {0.1e-15*w*l}
.ends sky130_fd_pr__model__parasitic__res_po
.lib "../sky130.lib.spice" tt

.include ../00_error_amp/design.cir
.include ../01_pass_device/design.cir
.include ../02_feedback_network/design.cir
.include ../03_compensation/design.cir

* ============================================================
* Core loop with CG NFET level shifter
* ============================================================
XM_pass gate bvdd pvdd pass_device
XEA avbg vfb ea_out pvdd 0 ibias en_ea error_amp
XFB pvdd vfb 0 feedback_network
XCOMP ea_out pvdd 0 compensation

* CG NFET level shifter (mimics startup circuit's MN_cg)
* drain=ea_out, gate=ls_bias, source=gate_node, bulk=gnd
* ls_bias set to ~5V via resistor divider + diode clamp from bvdd
* Pull-up: 100kΩ from bvdd to gate
XMcg ea_out ls_bias gate 0 sky130_fd_pr__nfet_g5v0d10v5 w=2e-6 l=4e-6

* ls_bias: simple divider — 5V bias point from BVDD
Rlb1 bvdd ls_bias 200k
Rlb2 ls_bias 0 500k

* Pull-up resistor from BVDD to gate
Rpu bvdd gate 100k

* ============================================================
* Stimuli
* ============================================================
Vbvdd bvdd 0 DC 7.0
Vavbg avbg 0 DC 1.226
Ibias ibias 0 DC 1u
Ven_ea en_ea 0 DC 7.0

Rload pvdd 0 500
Cout pvdd 0 1u

* ============================================================
* Simulation
* ============================================================
.option reltol=1e-4 abstol=1e-12 vntol=1e-6
.option method=gear
.option itl1=500 itl2=500

.ic V(pvdd)=5.0 V(ea_out)=1.0 V(gate)=5.5

.tran 1u 20m uic

.meas tran vpvdd_ss avg V(pvdd) from=18m to=20m
.meas tran vea_out_ss avg V(ea_out) from=18m to=20m
.meas tran vfb_ss avg V(vfb) from=18m to=20m
.meas tran vgate_ss avg V(gate) from=18m to=20m
.meas tran vls_bias avg V(ls_bias) from=18m to=20m

.control
run

echo "=== Core Loop + CG Level Shifter ==="
echo "vpvdd: $&vpvdd_ss"
echo "vea_out: $&vea_out_ss"
echo "vfb: $&vfb_ss"
echo "vgate: $&vgate_ss"
echo "vls_bias: $&vls_bias"

quit
.endc

.end

.title Bode_Plot_v5 — Direct open-loop gain measurement
.param mc_mm_switch = 0
.param MC_MM_SWITCH = 0
.subckt sky130_fd_pr__model__parasitic__res_po r0 r1 sub w=1 l=1
c0 r0 sub {0.1e-15*w*l}
c1 r1 sub {0.1e-15*w*l}
.ends
.lib "../sky130.lib.spice" tt
.temp 27
.include ../00_error_amp/design.cir
.include ../01_pass_device/design.cir
.include ../02_feedback_network/design.cir
.include ../03_compensation/design.cir
.include ../04_current_limiter/design.cir
.include ../05_uv_ov_comparators/design.cir
.include ../06_level_shifter/design.cir
.include ../07_zener_clamp/design.cir
.include ../08_mode_control/design.cir
.include ../09_startup/design.cir

* --- Open-loop: Break feedback, bias vfb at operating point ---
* At regulation: PVDD≈5V, vfb≈1.226V (= avbg)

* Soft-start (bias vref_ss at steady-state value)
Vref_ss vref_ss gnd 1.226

* Error amp: AC perturbation on vfb input
* vfb_ac has DC=1.226V (operating point) + AC=1
XEA vref_ss vfb_ac ea_out gnd ibias ea_en bvdd error_amp
Vfb_ac vfb_ac gnd DC 1.226 AC 1

* Compensation
XCOMP ea_out pvdd gnd compensation

* Pass device
XM_pass ea_out bvdd pvdd pass_device

* Current limiter
Iibias_ilim 0 ibias_ilim 1u
XILIM ea_out bvdd pvdd gnd ilim_flag ibias_ilim current_limiter

* Feedback - OPEN LOOP: don't connect vfb back
* Just monitor pvdd through the divider to see what vfb would be
XFB pvdd vfb_out gnd feedback_network
* FIX-24: Cfb removed; FIX-25: feedforward cap across R_TOP
Cff pvdd vfb_out 22p

* Zener
XZC pvdd gnd ibias zener_clamp

* EA enable
Ren_ea bvdd ea_en 100

* Startup (need to handle gate connection)
XSU bvdd pvdd ea_out gnd avbg startup_done su_ea_en ea_out startup

* Mode control
XMC bvdd pvdd svdd gnd en_ret bypass_en mc_ea_en ref_sel uvov_en ilim_en pass_off mode_control

* POR gate pullup
XMpo_invp pass_off_b pass_off bvdd bvdd sky130_fd_pr__pfet_g5v0d10v5 w=40e-6 l=2e-6
XMpo_invn pass_off_b pass_off gnd gnd sky130_fd_pr__nfet_g5v0d10v5 w=2e-6 l=2e-6
XMgate_pu ea_out pass_off_b bvdd bvdd sky130_fd_pr__pfet_g5v0d10v5 w=4e-6 l=2e-6

* UV/OV
XUV pvdd avbg uv_flag svdd gnd uvov_en uv_comparator
XOV pvdd avbg ov_flag svdd gnd uvov_en ov_comparator

* Level shifter
XLS_EN en en_bvdd bvdd svdd gnd level_shifter_up

* Output caps
Cload pvdd gnd 200e-12
Cout_ext pvdd gnd 1u

* Supplies
Vbvdd bvdd 0 7
Ven en 0 2.2
Vavbg avbg 0 1.226
Iibias 0 ibias 1u
Vsvdd svdd 0 2.2
Ven_ret en_ret 0 0
Rload pvdd 0 500

.option gmin=1e-10
.ac dec 50 1 10e6

.control
run
* Open-loop gain: perturbation at vfb → output at vfb_out
* Loop gain T = -vfb_out/vfb_ac (negative because negative feedback)
* Since Vfb_ac is the source, v(vfb_ac)=1 at all freq
let loop_gain_db = db(v(vfb_out))
let loop_phase = 180 + 180/3.14159*ph(v(vfb_out))
wrdata bode_data.txt loop_gain_db loop_phase
quit
.endc
.end

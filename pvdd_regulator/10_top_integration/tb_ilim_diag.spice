* Diagnose current limiter: check sense_out and det_n at each load
.title ILIM_DIAG
.subckt sky130_fd_pr__model__parasitic__res_po r0 r1 sub w=1 l=1
c0 r0 sub {0.1e-15*w*l}
c1 r1 sub {0.1e-15*w*l}
.ends sky130_fd_pr__model__parasitic__res_po
.lib "sky130_top.lib.spice" tt
.include ../00_error_amp/design.cir
.include ../01_pass_device/design.cir
.include ../02_feedback_network/design.cir
.include ../03_compensation/design.cir
.include ../04_current_limiter/design.cir
.include ../05_uv_ov_comparators/design.cir
.include ../06_level_shifter/design.cir
.include ../07_zener_clamp/design.cir
.include ../08_mode_control/design.cir
.include ../09_startup/design.cir
.include design.cir

Vbvdd bvdd 0 PWL(0 0 10u 7 100 7)
Vavbg avbg 0 1.226
Iibias 0 ibias 1u
Vsvdd svdd 0 2.2
Ven en 0 PWL(0 0 0.5u 0 1u 2.2)
Ven_ret en_ret 0 0

* Stepped loads: 1, 5, 10, 15, 17, 18, 19, 20 mA
Rbase pvdd 0 5000
Iextra pvdd 0 PWL(0 0 19.99m 0 20m 4m 39.99m 4m 40m 9m 59.99m 9m 60m 14m 79.99m 14m 80m 16m 99.99m 16m 100m 17m 119.99m 17m 120m 18m 139.99m 18m 140m 19m 160m 19m)

XDUT bvdd pvdd 0 avbg ibias svdd en en_ret uv_flag ov_flag startup_done pvdd_regulator

.option gmin=1e-10 method=gear reltol=1e-3 abstol=1e-10 vntol=1e-4
.ic V(pvdd)=0 V(bvdd)=0
.tran 10u 160m uic

.control
run
echo "=== Load | PVDD | Gate | sense_out | det_n | cas_bias | ibias ==="
echo "1mA (t=18ms):"
print v(pvdd)[1800] v(xdut.gate)[1800] v(xdut.xilim.sense_out)[1800] v(xdut.xilim.det_n)[1800] v(xdut.xilim.cas_bias)[1800] v(ibias)[1800]
echo "5mA (t=38ms):"
print v(pvdd)[3800] v(xdut.gate)[3800] v(xdut.xilim.sense_out)[3800] v(xdut.xilim.det_n)[3800] v(xdut.xilim.cas_bias)[3800]
echo "10mA (t=58ms):"
print v(pvdd)[5800] v(xdut.gate)[5800] v(xdut.xilim.sense_out)[5800] v(xdut.xilim.det_n)[5800]
echo "15mA (t=78ms):"
print v(pvdd)[7800] v(xdut.gate)[7800] v(xdut.xilim.sense_out)[7800] v(xdut.xilim.det_n)[7800]
echo "17mA (t=98ms):"
print v(pvdd)[9800] v(xdut.gate)[9800] v(xdut.xilim.sense_out)[9800] v(xdut.xilim.det_n)[9800]
echo "18mA (t=118ms):"
print v(pvdd)[11800] v(xdut.gate)[11800] v(xdut.xilim.sense_out)[11800] v(xdut.xilim.det_n)[11800]
echo "19mA (t=138ms):"
print v(pvdd)[13800] v(xdut.gate)[13800] v(xdut.xilim.sense_out)[13800] v(xdut.xilim.det_n)[13800]
echo "20mA (t=158ms):"
print v(pvdd)[15800] v(xdut.gate)[15800] v(xdut.xilim.sense_out)[15800] v(xdut.xilim.det_n)[15800]
quit
.endc
.end

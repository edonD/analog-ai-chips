* V7 Verification — DC Regulation + Startup Transient
* Tests: DC at 0mA, 1mA, 10mA, 50mA loads; startup overshoot
* PVDD 5V LDO Regulator — SkyWater SKY130A

* === PDK and models ===
.param mc_mm_switch = 0
.param MC_MM_SWITCH = 0
.subckt sky130_fd_pr__model__parasitic__res_po r0 r1 sub w=1 l=1
c0 r0 sub {0.1e-15*w*l}
c1 r1 sub {0.1e-15*w*l}
.ends sky130_fd_pr__model__parasitic__res_po
.lib "../sky130.lib.spice" tt
.include "/home/ubuntu/.volare/volare/sky130/versions/0fe599b2afb6708d281543108caf8310912f54af/sky130A/libs.tech/ngspice/parameters/invariant.spice"
.include "/home/ubuntu/.volare/volare/sky130/versions/0fe599b2afb6708d281543108caf8310912f54af/sky130A/libs.ref/sky130_fd_pr/spice/sky130_fd_pr__nfet_01v8__tt.pm3.spice"
.include "/home/ubuntu/.volare/volare/sky130/versions/0fe599b2afb6708d281543108caf8310912f54af/sky130A/libs.ref/sky130_fd_pr/spice/sky130_fd_pr__pfet_01v8__tt.corner.spice"

* === Block includes ===
.include ../00_error_amp/design.cir
.include ../01_pass_device/design.cir
.include ../02_feedback_network/design.cir
.include ../03_compensation/design.cir
.include ../04_current_limiter/design.cir
.include ../05_uv_ov_comparators/design.cir
.include ../06_level_shifter/design.cir
.include ../07_zener_clamp/design.cir
.include ../08_mode_control/design.cir
.include ../09_startup/design.cir

* === Flat wiring (v7 topology) ===
XM_pass gate bvdd pvdd pass_device
Rss avbg vref_ss 100k
Css vref_ss 0 10n
XEA vref_ss vfb ea_out pvdd 0 ibias bvdd bvdd error_amp
XFB pvdd vfb 0 feedback_network
XCOMP ea_out pvdd 0 compensation
XILIM gate bvdd pvdd 0 ilim_flag current_limiter
XUV pvdd avbg uv_flag svdd 0 uvov_en uv_comparator
XOV pvdd avbg ov_flag svdd 0 uvov_en ov_comparator
XZC pvdd 0 zener_clamp
XMC bvdd pvdd svdd 0 en_ret bypass_en mc_ea_en ref_sel uvov_en ilim_en pass_off mode_control
XSU bvdd pvdd gate 0 avbg startup_done bvdd ea_out startup
XLS_EN en en_bvdd bvdd svdd 0 level_shifter_up
Cload pvdd 0 200e-12
Cout_ext pvdd 0 1u

* === Load: 1mA nominal, stepped via current source ===
* Start at no-load, step through loads at different times
* 0-100ms: no load (settle)
* 100-200ms: 1mA
* 200-300ms: 10mA
* 300-500ms: 50mA
Iload pvdd 0 PWL(0 0 100m 0 100.001m 1m 200m 1m 200.001m 10m 300m 10m 300.001m 50m 500m 50m)

* === Stimuli ===
* BVDD: ramp 0→7V in 10µs, hold at 7V
Vbvdd bvdd 0 PWL(0 0 10u 7 500m 7)
Vavbg avbg 0 1.226
Ibias 0 ibias DC 1u
Vsvdd svdd 0 2.2
Ven en 0 PWL(0 0 0.5u 0 1u 2.2)
Ven_ret en_ret 0 0

* === Convergence options ===
.option reltol=1e-4 abstol=1e-12 vntol=1e-6
.option method=gear maxord=2
.option itl1=500 itl2=500 itl4=500
.option gmin=1e-12

* === Initial conditions ===
.ic V(pvdd)=0 V(bvdd)=0 V(vref_ss)=0

* === Transient analysis: 500ms total ===
.tran 10u 500m uic

* === Measurements ===
* DC regulation at each load
.meas tran vpvdd_noload avg V(pvdd) from=80m to=99m
.meas tran vpvdd_1ma avg V(pvdd) from=180m to=199m
.meas tran vpvdd_10ma avg V(pvdd) from=280m to=299m
.meas tran vpvdd_50ma avg V(pvdd) from=380m to=499m

* Startup overshoot
.meas tran vpvdd_peak max V(pvdd) from=0 to=100m

* Key internal node voltages (for debugging EA bias)
.meas tran v_ea_out avg V(ea_out) from=80m to=99m
.meas tran v_gate avg V(gate) from=80m to=99m
.meas tran v_vfb avg V(vfb) from=80m to=99m
.meas tran v_vref_ss avg V(vref_ss) from=80m to=99m

.control
run
* Print measurements
print vpvdd_noload vpvdd_1ma vpvdd_10ma vpvdd_50ma
print vpvdd_peak
print v_ea_out v_gate v_vfb v_vref_ss

* Save waveform data
wrdata tb_v7_dc_startup.raw V(pvdd) V(ea_out) V(gate) V(vref_ss) V(vfb)
quit
.endc
.end

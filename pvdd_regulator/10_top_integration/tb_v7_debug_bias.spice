* V7 Debug — EA Bias Point Analysis
* Pre-charge PVDD to 5V, check if EA regulates
* PVDD 5V LDO Regulator — SkyWater SKY130A

* === PDK and models ===
.param mc_mm_switch = 0
.param MC_MM_SWITCH = 0
.subckt sky130_fd_pr__model__parasitic__res_po r0 r1 sub w=1 l=1
c0 r0 sub {0.1e-15*w*l}
c1 r1 sub {0.1e-15*w*l}
.ends sky130_fd_pr__model__parasitic__res_po
.lib "../sky130.lib.spice" tt
.include "/home/ubuntu/.volare/volare/sky130/versions/0fe599b2afb6708d281543108caf8310912f54af/sky130A/libs.tech/ngspice/parameters/invariant.spice"
.include "/home/ubuntu/.volare/volare/sky130/versions/0fe599b2afb6708d281543108caf8310912f54af/sky130A/libs.ref/sky130_fd_pr/spice/sky130_fd_pr__nfet_01v8__tt.pm3.spice"
.include "/home/ubuntu/.volare/volare/sky130/versions/0fe599b2afb6708d281543108caf8310912f54af/sky130A/libs.ref/sky130_fd_pr/spice/sky130_fd_pr__pfet_01v8__tt.corner.spice"

* === Block includes ===
.include ../00_error_amp/design.cir
.include ../01_pass_device/design.cir
.include ../02_feedback_network/design.cir
.include ../03_compensation/design.cir
.include ../04_current_limiter/design.cir
.include ../05_uv_ov_comparators/design.cir
.include ../06_level_shifter/design.cir
.include ../07_zener_clamp/design.cir
.include ../08_mode_control/design.cir
.include ../09_startup/design.cir

* === Flat wiring (v7 topology) ===
XM_pass gate bvdd pvdd pass_device
Rss avbg vref_ss 100k
Css vref_ss 0 10n
XEA vref_ss vfb ea_out pvdd 0 ibias bvdd bvdd error_amp
XFB pvdd vfb 0 feedback_network
XCOMP ea_out pvdd 0 compensation
XILIM gate bvdd pvdd 0 ilim_flag current_limiter
XUV pvdd avbg uv_flag svdd 0 uvov_en uv_comparator
XOV pvdd avbg ov_flag svdd 0 uvov_en ov_comparator
XZC pvdd 0 zener_clamp
XMC bvdd pvdd svdd 0 avbg en_ret bypass_en mc_ea_en ref_sel uvov_en ilim_en pass_off mode_control
XSU bvdd pvdd gate 0 avbg startup_done bvdd ea_out startup
XLS_EN en en_bvdd bvdd svdd 0 level_shifter_up
Cload pvdd 0 200e-12
Cout_ext pvdd 0 1u

* No load
Rload pvdd 0 1G

* === Stimuli — BVDD = 7V, PVDD pre-charged to 5V ===
Vbvdd bvdd 0 7
Vavbg avbg 0 1.226
Ibias ibias 0 DC 1u
Vsvdd svdd 0 2.2
Ven en 0 2.2
Ven_ret en_ret 0 0

* === Convergence options ===
.option reltol=1e-4 abstol=1e-12 vntol=1e-6
.option method=gear maxord=2
.option itl1=500 itl2=500 itl4=500
.option gmin=1e-12

* Pre-charge PVDD and vref_ss
.ic V(pvdd)=5 V(vref_ss)=1.226 V(bvdd)=7

.tran 1u 50m uic

* === Measurements — steady-state at end ===
.meas tran vpvdd avg V(pvdd) from=40m to=50m
.meas tran v_ea_out avg V(ea_out) from=40m to=50m
.meas tran v_gate avg V(gate) from=40m to=50m
.meas tran v_vfb avg V(vfb) from=40m to=50m
.meas tran v_d2 avg V(XEA.d2) from=40m to=50m
.meas tran v_d1 avg V(XEA.d1) from=40m to=50m
.meas tran v_ibias_en avg V(XEA.ibias_en) from=40m to=50m
.meas tran v_pb_tail avg V(XEA.pb_tail) from=40m to=50m
.meas tran v_tail_s avg V(XEA.tail_s) from=40m to=50m

.control
run
quit
.endc
.end

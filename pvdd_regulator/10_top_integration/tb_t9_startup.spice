* Test T9: Fast Startup — BVDD ramp 10V/us
.title T9 Fast Startup Check

.param mc_mm_switch = 0
.param MC_MM_SWITCH = 0
.subckt sky130_fd_pr__model__parasitic__res_po r0 r1 sub w=1 l=1
c0 r0 sub {0.1e-15*w*l}
c1 r1 sub {0.1e-15*w*l}
.ends sky130_fd_pr__model__parasitic__res_po
.lib "../sky130.lib.spice" tt

.include ../00_error_amp/design.cir
.include ../01_pass_device/design.cir
.include ../02_feedback_network/design.cir
.include ../03_compensation/design.cir
.include ../04_current_limiter/design.cir
.include ../05_uv_ov_comparators/design.cir
.include ../06_level_shifter/design.cir
.include ../07_zener_clamp/design.cir
.include ../08_mode_control/design.cir
.include ../09_startup/design.cir
.include design.cir

* Supplies: BVDD ramps 0 → 10.5V at 10V/us (1.05us ramp)
Vbvdd bvdd 0 PWL(0 0 1.05u 10.5)
Vavbg avbg 0 1.226
Iibias 0 ibias 1u
Vsvdd svdd 0 2.2
Ven en 0 2.2
Ven_ret en_ret 0 0

* Load: 1mA
Rload pvdd 0 5000

* DUT
XDUT bvdd pvdd 0 avbg ibias svdd en en_ret uv_flag ov_flag startup_done pvdd_regulator

.option gmin=1e-10 method=gear reltol=1e-3 abstol=1e-10 vntol=1e-4
.tran 0.1u 50u
.control
run
echo "=== T9 FAST STARTUP ==="
meas tran pvdd_max MAX v(pvdd)
meas tran pvdd_final FIND v(pvdd) AT=50u
meas tran bvdd_final FIND v(bvdd) AT=50u
print pvdd_max pvdd_final bvdd_final
echo "=== END ==="
quit
.endc
.end

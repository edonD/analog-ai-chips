* Task 1: DC operating point check
.title PVDD LDO DC Check

.param mc_mm_switch = 0
.param MC_MM_SWITCH = 0
.subckt sky130_fd_pr__model__parasitic__res_po r0 r1 sub w=1 l=1
c0 r0 sub {0.1e-15*w*l}
c1 r1 sub {0.1e-15*w*l}
.ends sky130_fd_pr__model__parasitic__res_po
.lib "../sky130.lib.spice" ss

.include ../00_error_amp/design.cir
.include ../01_pass_device/design.cir
.include ../02_feedback_network/design.cir
.include ../03_compensation/design.cir
.include ../04_current_limiter/design.cir
.include ../05_uv_ov_comparators/design.cir
.include ../06_level_shifter/design.cir
.include ../07_zener_clamp/design.cir
.include ../08_mode_control/design.cir
.include ../09_startup/design.cir
.include design.cir

* Supplies
Vbvdd bvdd 0 7
Vavbg avbg 0 1.226
Iibias 0 ibias 1u
Vsvdd svdd 0 2.2
Ven en 0 2.2
Ven_ret en_ret 0 0

* Load: 1mA
Rload pvdd 0 5000

* DUT
XDUT bvdd pvdd 0 avbg ibias svdd en en_ret uv_flag ov_flag startup_done pvdd_regulator

.nodeset v(pvdd)=5.0 v(xdut.gate)=6.0
.option gmin=1e-10 method=gear reltol=1e-3 abstol=1e-10 vntol=1e-4
.nodeset v(pvdd)=5.0 v(xdut.gate)=6.0
.op
.control
op
echo "=== DC OPERATING POINT ==="
print v(pvdd) v(xdut.vref_ss) v(xdut.vfb) v(xdut.ea_out) v(xdut.gate) v(xdut.ea_en)
print v(xdut.xea.d1) v(xdut.xea.d2) v(xdut.xea.ibias_en)
print @m.xdut.xea.xmcs_n.msky130_fd_pr__nfet_g5v0d10v5[id]
print @m.xdut.xea.xmcs_p.msky130_fd_pr__pfet_g5v0d10v5[id]
echo "=== GATE DEBUG ==="
print v(xdut.xsu.det_n) v(xdut.xsu.sense_mid)
print v(xdut.xilim.det_n) v(xdut.xilim.sense_n)
print @m.xdut.xilim.xmclamp.msky130_fd_pr__pfet_g5v0d10v5[id]
print @m.xdut.xsu.xmsu_pd.msky130_fd_pr__nfet_g5v0d10v5[id]
echo "=== END ==="
quit
.endc
.end

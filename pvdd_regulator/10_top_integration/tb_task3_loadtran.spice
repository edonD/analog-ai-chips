* Task 3: Load Transient Verification
* Step 1mA → 10mA at 50us, back to 1mA at 150us
* PASS: undershoot < 150mV

.param mc_mm_switch = 0
.param MC_MM_SWITCH = 0
.subckt sky130_fd_pr__model__parasitic__res_po r0 r1 sub w=1 l=1
c0 r0 sub {0.1e-15*w*l}
c1 r1 sub {0.1e-15*w*l}
.ends sky130_fd_pr__model__parasitic__res_po
.lib "../sky130.lib.spice" tt

.include ../00_error_amp/design.cir
.include ../01_pass_device/design.cir
.include ../02_feedback_network/design.cir
.include ../03_compensation/design.cir
.include ../04_current_limiter/design.cir
.include ../05_uv_ov_comparators/design.cir
.include ../06_level_shifter/design.cir
.include ../07_zener_clamp/design.cir
.include ../08_mode_control/design.cir
.include ../09_startup/design.cir
.include design.cir

* Supply setup
Vbvdd bvdd 0 7
Vavbg avbg 0 1.226
Iibias 0 ibias 1u
Vsvdd svdd 0 2.2
Ven en 0 2.2
Ven_ret en_ret 0 0
XDUT bvdd pvdd 0 avbg ibias svdd en en_ret uv_flag ov_flag startup_done pvdd_regulator

* Load: pulsed current source
Iload pvdd 0 PWL(0 1m 50u 1m 51u 10m 150u 10m 151u 1m)

* Convergence aid
.nodeset v(pvdd)=5.0
.option gmin=1e-10 method=gear reltol=1e-3 abstol=1e-10 vntol=1e-4

.tran 0.1u 200u

.control
run
meas tran pvdd_ss AVG v(pvdd) from=40u to=49u
meas tran pvdd_min MIN v(pvdd) from=50u to=100u
meas tran pvdd_max MAX v(pvdd) from=150u to=200u
let undershoot = pvdd_ss - pvdd_min
let overshoot = pvdd_max - pvdd_ss
echo "==== LOAD TRANSIENT RESULTS ===="
print pvdd_ss pvdd_min pvdd_max undershoot overshoot
echo "==== END ===="
quit
.endc

.end

* Diagnose: fine-grained load sweep 30-60mA with internal nodes
.title ILIM_DIAG2
.subckt sky130_fd_pr__model__parasitic__res_po r0 r1 sub w=1 l=1
c0 r0 sub {0.1e-15*w*l}
c1 r1 sub {0.1e-15*w*l}
.ends sky130_fd_pr__model__parasitic__res_po
.lib "sky130_top.lib.spice" tt
.include ../00_error_amp/design.cir
.include ../01_pass_device/design.cir
.include ../02_feedback_network/design.cir
.include ../03_compensation/design.cir
.include ../04_current_limiter/design.cir
.include ../05_uv_ov_comparators/design.cir
.include ../06_level_shifter/design.cir
.include ../07_zener_clamp/design.cir
.include ../08_mode_control/design.cir
.include ../09_startup/design.cir
.include design.cir
Vbvdd bvdd 0 PWL(0 0 10u 7 100 7)
Vavbg avbg 0 1.226
Iibias 0 ibias 1u
Vsvdd svdd 0 2.2
Ven en 0 PWL(0 0 0.5u 0 1u 2.2)
Ven_ret en_ret 0 0
Rbase pvdd 0 5000
* Steps: 30, 33, 35, 37, 39, 40, 42, 44, 46, 48, 50 mA total
Iextra pvdd 0 PWL(0 0 19.99m 0 20m 29m 39.99m 29m 40m 32m 59.99m 32m 60m 34m 79.99m 34m 80m 36m 99.99m 36m 100m 38m 119.99m 38m 120m 39m 139.99m 39m 140m 41m 159.99m 41m 160m 43m 179.99m 43m 180m 45m 199.99m 45m 200m 47m 219.99m 47m 220m 49m 240m 49m)
XDUT bvdd pvdd 0 avbg ibias svdd en en_ret uv_flag ov_flag startup_done pvdd_regulator
.option gmin=1e-10 method=gear reltol=1e-3 abstol=1e-10 vntol=1e-4
.ic V(pvdd)=0 V(bvdd)=0
.tran 10u 240m uic
.control
run
echo "=== Fine sweep around trip point ==="
echo "30mA (t=38ms):"
print v(pvdd)[3800] v(xdut.xilim.sense_out)[3800] v(ibias)[3800]
echo "33mA (t=58ms):"
print v(pvdd)[5800] v(xdut.xilim.sense_out)[5800]
echo "35mA (t=78ms):"
print v(pvdd)[7800] v(xdut.xilim.sense_out)[7800]
echo "37mA (t=98ms):"
print v(pvdd)[9800] v(xdut.xilim.sense_out)[9800]
echo "39mA (t=118ms):"
print v(pvdd)[11800] v(xdut.xilim.sense_out)[11800]
echo "40mA (t=138ms):"
print v(pvdd)[13800] v(xdut.xilim.sense_out)[13800]
echo "42mA (t=158ms):"
print v(pvdd)[15800] v(xdut.xilim.sense_out)[15800]
echo "44mA (t=178ms):"
print v(pvdd)[17800] v(xdut.xilim.sense_out)[17800]
echo "46mA (t=198ms):"
print v(pvdd)[19800] v(xdut.xilim.sense_out)[19800]
echo "48mA (t=218ms):"
print v(pvdd)[21800] v(xdut.xilim.sense_out)[21800]
echo "50mA (t=238ms):"
print v(pvdd)[23800] v(xdut.xilim.sense_out)[23800]
quit
.endc
.end

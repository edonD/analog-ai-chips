* Test T18: Power Consumption — all operating modes
* Measure total BVDD current at different conditions
* Report only, no numeric limit
.title PVDD LDO T18 Power Consumption

.param mc_mm_switch = 0
.param MC_MM_SWITCH = 0
.subckt sky130_fd_pr__model__parasitic__res_po r0 r1 sub w=1 l=1
c0 r0 sub {0.1e-15*w*l}
c1 r1 sub {0.1e-15*w*l}
.ends sky130_fd_pr__model__parasitic__res_po
.lib "../sky130.lib.spice" tt

.include ../00_error_amp/design.cir
.include ../01_pass_device/design.cir
.include ../02_feedback_network/design.cir
.include ../03_compensation/design.cir
.include ../04_current_limiter/design.cir
.include ../05_uv_ov_comparators/design.cir
.include ../06_level_shifter/design.cir
.include ../07_zener_clamp/design.cir
.include ../08_mode_control/design.cir
.include ../09_startup/design.cir
.include design.cir

* Supplies — BVDD=7V, normal regulation
Vbvdd bvdd 0 7
Vavbg avbg 0 1.226
Iibias 0 ibias 1u
Vsvdd svdd 0 2.2
Ven en 0 2.2
Ven_ret en_ret 0 0

* DUT
XDUT bvdd pvdd 0 avbg ibias svdd en en_ret uv_flag ov_flag pvdd_regulator

* No-load (high-R to avoid floating)
Rload pvdd 0 10meg

.option gmin=1e-10 method=gear reltol=1e-3 abstol=1e-10 vntol=1e-4

.op

.control
run
echo "=== TEST T18: POWER CONSUMPTION — NO LOAD ==="
let ibvdd_noload = -i(Vbvdd)
let ibvdd_noload_ua = ibvdd_noload * 1e6
let pvdd_v = v(pvdd)
echo "PVDD = $&pvdd_v V"
echo "BVDD current (no load) = $&ibvdd_noload_ua uA"
let power_noload_uw = ibvdd_noload * 7 * 1e6
echo "Power (no load) = $&power_noload_uw uW"
echo "RESULT: Report only — no numeric limit"
quit
.endc
.end

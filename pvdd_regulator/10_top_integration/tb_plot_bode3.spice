.title Bode_Plot_v3 — Open-loop via STB method approximation
.param mc_mm_switch = 0
.param MC_MM_SWITCH = 0
.subckt sky130_fd_pr__model__parasitic__res_po r0 r1 sub w=1 l=1
c0 r0 sub {0.1e-15*w*l}
c1 r1 sub {0.1e-15*w*l}
.ends
.lib "../sky130.lib.spice" tt
.temp 27
.include ../00_error_amp/design.cir
.include ../01_pass_device/design.cir
.include ../02_feedback_network/design.cir
.include ../03_compensation/design.cir
.include ../04_current_limiter/design.cir
.include ../05_uv_ov_comparators/design.cir
.include ../06_level_shifter/design.cir
.include ../07_zener_clamp/design.cir
.include ../08_mode_control/design.cir
.include ../09_startup/design.cir
.include design.cir

* AC perturbation on reference voltage
Vbvdd bvdd 0 DC 7
Ven en 0 2.2
Vavbg avbg 0 DC 1.226 AC 1
Iibias 0 ibias 1u
Vsvdd svdd 0 2.2
Ven_ret en_ret 0 0
Rload pvdd 0 500

XDUT bvdd pvdd 0 avbg ibias svdd en en_ret uv_flag ov_flag startup_done pvdd_regulator

.option gmin=1e-10
.ac dec 50 1 10e6

.control
run
* Closed-loop gain: T_CL = v(pvdd)/v(avbg)
* For an LDO with feedback factor beta, T_CL = A/(1+A*beta)
* At low freq where A>>1: T_CL ≈ 1/beta = Vout/Vref ≈ 5.0/1.226 ≈ 4.08 ≈ 12.2dB
* Loop gain T = A*beta can be estimated as T = T_CL * beta / (1 - beta*T_CL/T_CL)
* But simpler: just plot closed-loop gain magnitude and phase
let cl_gain_db = db(v(pvdd)/v(avbg))
let cl_phase = 180/3.14159*ph(v(pvdd)/v(avbg))
wrdata bode_data.txt cl_gain_db cl_phase
quit
.endc
.end

* Full Verification: All key specs
* Pattern from working T11/T16 tests (no extra PDK includes)
.title PVDD LDO Full Verification

.param mc_mm_switch = 0
.param MC_MM_SWITCH = 0
.subckt sky130_fd_pr__model__parasitic__res_po r0 r1 sub w=1 l=1
c0 r0 sub {0.1e-15*w*l}
c1 r1 sub {0.1e-15*w*l}
.ends sky130_fd_pr__model__parasitic__res_po
.lib "../sky130.lib.spice" tt

.include ../00_error_amp/design.cir
.include ../01_pass_device/design.cir
.include ../02_feedback_network/design.cir
.include ../03_compensation/design.cir
.include ../04_current_limiter/design.cir
.include ../05_uv_ov_comparators/design.cir
.include ../06_level_shifter/design.cir
.include ../07_zener_clamp/design.cir
.include ../08_mode_control/design.cir
.include ../09_startup/design.cir

* Flat wiring (same as design.cir but flat for .meas access)
XM_pass gate bvdd pvdd pass_device
Rss avbg vref_ss 100k
Css vref_ss 0 10n
XEA vref_ss vfb ea_out pvdd 0 ibias bvdd bvdd error_amp
XFB pvdd vfb 0 feedback_network
XCOMP ea_out pvdd 0 compensation
XILIM gate bvdd pvdd 0 ilim_flag current_limiter
XUV pvdd avbg uv_flag svdd 0 uvov_en uv_comparator
XOV pvdd avbg ov_flag svdd 0 uvov_en ov_comparator
XZC pvdd 0 zener_clamp
XMC bvdd pvdd svdd 0 avbg en_ret bypass_en mc_ea_en ref_sel uvov_en ilim_en pass_off mode_control
XSU bvdd pvdd gate 0 avbg startup_done bvdd ea_out startup
XLS_EN en en_bvdd bvdd svdd 0 level_shifter_up
Cload pvdd 0 200e-12
Cout_ext pvdd 0 1u

* Load: start at 1mA (5k), step to test transient
Rload pvdd 0 5k

* Step current: sweeps through load conditions
* 0-50ms: 1mA (Rload only)
* 50ms: add 9mA step (total 10mA)
* 100ms: remove 9mA step
* 150ms: add 49mA step (total 50mA)  *** CRITICAL TEST ***
* 200ms: remove 49mA step
Istep pvdd 0 PWL(0 0 50m 0 50.001m 9m 100m 9m 100.001m 0 150m 0 150.001m 49m 200m 49m 200.001m 0 250m 0)

* Stimuli: BVDD ramps 0->7V in 10us (startup test)
Vbvdd bvdd 0 PWL(0 0 10u 7 300m 7)
Vavbg avbg 0 1.226
Ibias ibias 0 DC 1u
Vsvdd svdd 0 2.2
Ven en 0 PWL(0 0 0.5u 0 1u 2.2)
Ven_ret en_ret 0 0

.option reltol=1e-4 abstol=1e-12 vntol=1e-6
.option method=gear maxord=2
.option itl1=500 itl2=500 itl4=500
.option gmin=1e-10

.ic V(pvdd)=0 V(bvdd)=0
.tran 5u 280m uic

* T1: DC regulation at various loads
.meas tran vpvdd_1ma avg V(pvdd) from=40m to=50m
.meas tran vpvdd_10ma avg V(pvdd) from=90m to=100m
.meas tran vpvdd_50ma avg V(pvdd) from=190m to=200m
.meas tran vpvdd_1ma_back avg V(pvdd) from=240m to=250m

* T2: Startup
.meas tran pvdd_peak MAX V(pvdd) from=0 to=50m
.meas tran t_start WHEN V(pvdd)=4.5 RISE=1

* T3: Load transient undershoot/overshoot (50mA step at 150ms)
.meas tran v_before_step avg V(pvdd) from=149m to=150m
.meas tran v_min_50ma MIN V(pvdd) from=150m to=160m
.meas tran v_max_release MAX V(pvdd) from=200m to=210m
.meas tran v_after_release avg V(pvdd) from=248m to=250m

* T3: Load transient undershoot/overshoot (10mA step at 50ms)
.meas tran v_before_10ma avg V(pvdd) from=49m to=50m
.meas tran v_min_10ma MIN V(pvdd) from=50m to=60m
.meas tran v_max_10ma MAX V(pvdd) from=100m to=110m

* Iq: measure BVDD current during 1mA-only phase
.meas tran ibvdd_1ma avg I(Vbvdd) from=40m to=50m

.control
run
quit
.endc
.end

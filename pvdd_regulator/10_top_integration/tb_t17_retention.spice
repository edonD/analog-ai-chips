* Test T17: Retention Mode — BVDD=3.5V, Iload=0.5mA
* PVDD should track BVDD (bypass mode) since BVDD < dropout
* Report-only: document what happens
.title PVDD LDO T17 Retention Mode

.param mc_mm_switch = 0
.param MC_MM_SWITCH = 0
.subckt sky130_fd_pr__model__parasitic__res_po r0 r1 sub w=1 l=1
c0 r0 sub {0.1e-15*w*l}
c1 r1 sub {0.1e-15*w*l}
.ends sky130_fd_pr__model__parasitic__res_po
.lib "../sky130.lib.spice" tt

.include ../00_error_amp/design.cir
.include ../01_pass_device/design.cir
.include ../02_feedback_network/design.cir
.include ../03_compensation/design.cir
.include ../04_current_limiter/design.cir
.include ../05_uv_ov_comparators/design.cir
.include ../06_level_shifter/design.cir
.include ../07_zener_clamp/design.cir
.include ../08_mode_control/design.cir
.include ../09_startup/design.cir
.include design.cir

* Supplies — BVDD only 3.5V (below regulation, retention/bypass mode)
Vbvdd bvdd 0 PWL(0 0 10u 3.5 200m 3.5)
Vavbg avbg 0 1.226
Iibias 0 ibias 1u
Vsvdd svdd 0 2.2
Ven en 0 PWL(0 0 0.5u 0 1u 2.2)
Ven_ret en_ret 0 2.2

* DUT
XDUT bvdd pvdd 0 avbg ibias svdd en en_ret uv_flag ov_flag startup_done pvdd_regulator

* Light load: 0.5mA
Rload pvdd 0 7k

.option reltol=1e-3 abstol=1e-10 vntol=1e-4
.option method=gear maxord=2
.option itl1=500 itl2=500 itl4=500

.ic V(pvdd)=0 V(bvdd)=0
.tran 10u 200m uic

.meas tran pvdd_ss avg V(pvdd) from=180m to=200m
.meas tran bvdd_ss avg V(bvdd) from=180m to=200m
.meas tran dropout param='bvdd_ss - pvdd_ss'

.control
run
echo "=== TEST T17: RETENTION MODE ==="
echo "BVDD = $&bvdd_ss V"
echo "PVDD = $&pvdd_ss V"
echo "Dropout = $&dropout V"
let tracking = pvdd_ss / bvdd_ss * 100
echo "PVDD/BVDD ratio = $&tracking %"
echo "NOTE: Retention mode test — report only, no numeric pass/fail limit"
if pvdd_ss > 2.5
  echo "RESULT: PVDD > 2.5V — regulator passes through some voltage"
else
  echo "RESULT: PVDD <= 2.5V — regulator may not be in bypass mode"
end
quit
.endc
.end

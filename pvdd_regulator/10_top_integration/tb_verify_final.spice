* FINAL Verification: Full startup + load sweep
* Measures: T1 DC reg, T2 startup, T3 transient, T16 Iq
.title PVDD LDO Final Verification

.param mc_mm_switch = 0
.param MC_MM_SWITCH = 0
.subckt sky130_fd_pr__model__parasitic__res_po r0 r1 sub w=1 l=1
c0 r0 sub {0.1e-15*w*l}
c1 r1 sub {0.1e-15*w*l}
.ends sky130_fd_pr__model__parasitic__res_po
.lib "../sky130.lib.spice" tt

.include ../00_error_amp/design.cir
.include ../01_pass_device/design.cir
.include ../02_feedback_network/design.cir
.include ../03_compensation/design.cir
.include ../04_current_limiter/design.cir
.include ../05_uv_ov_comparators/design.cir
.include ../06_level_shifter/design.cir
.include ../07_zener_clamp/design.cir
.include ../08_mode_control/design.cir
.include ../09_startup/design.cir

* Flat wiring
XM_pass gate bvdd pvdd pass_device
Rss avbg vref_ss 100k
Css vref_ss 0 10n
XEA vref_ss vfb ea_out pvdd 0 ibias bvdd bvdd error_amp
XFB pvdd vfb 0 feedback_network
XCOMP ea_out pvdd 0 compensation
XILIM gate bvdd pvdd 0 ilim_flag current_limiter
XUV pvdd avbg uv_flag svdd 0 uvov_en uv_comparator
XOV pvdd avbg ov_flag svdd 0 uvov_en ov_comparator
XZC pvdd 0 zener_clamp
XMC bvdd pvdd svdd 0 avbg en_ret bypass_en mc_ea_en ref_sel uvov_en ilim_en pass_off mode_control
XSU bvdd pvdd gate 0 avbg startup_done bvdd ea_out startup
XLS_EN en en_bvdd bvdd svdd 0 level_shifter_up
Cload pvdd 0 200e-12
Cout_ext pvdd 0 1u

* Resistive load: 10mA
Rload pvdd 0 500

* Step current for 50mA test:
*   0-100ms: settling with 10mA (Rload only)
*   100ms: add 40mA (total 50mA) for 50ms
*   150ms: remove 40mA step, back to 10mA
Istep pvdd 0 PWL(0 0 100m 0 100.001m 40m 150m 40m 150.001m 0 200m 0)

* Stimuli: BVDD ramps 0->7V in 10us
Vbvdd bvdd 0 PWL(0 0 10u 7 200m 7)
Vavbg avbg 0 1.226
Ibias ibias 0 DC 1u
Vsvdd svdd 0 2.2
Ven en 0 PWL(0 0 0.5u 0 1u 2.2)
Ven_ret en_ret 0 0

.option reltol=1e-4 abstol=1e-12 vntol=1e-6
.option method=gear maxord=2 gmin=1e-10
.option itl1=500 itl2=500 itl4=500

.ic V(pvdd)=0 V(bvdd)=0
.tran 5u 200m uic

* T1: DC regulation at 10mA
.meas tran vpvdd_10ma avg V(pvdd) from=90m to=100m

* T1: DC regulation at 50mA (CRITICAL)
.meas tran vpvdd_50ma avg V(pvdd) from=140m to=150m

* T1: Back to 10mA after 50mA step
.meas tran vpvdd_recovery avg V(pvdd) from=190m to=200m

* T2: Startup
.meas tran pvdd_peak MAX V(pvdd) from=0 to=50m
.meas tran t_start WHEN V(pvdd)=4.5 RISE=1

* T3: Transient (40mA step at 100ms)
.meas tran v_before avg V(pvdd) from=99m to=100m
.meas tran v_undershoot MIN V(pvdd) from=100m to=110m
.meas tran v_overshoot MAX V(pvdd) from=150m to=160m
.meas tran v_after avg V(pvdd) from=155m to=160m

* Iq: total BVDD current at 10mA load phase
.meas tran ibvdd_10ma avg I(Vbvdd) from=90m to=100m

* Debug: sense_n at 50mA to verify limiter not tripping
.meas tran sense_n_50ma avg V(xilim.sense_n) from=140m to=150m
.meas tran vfb_10ma avg V(vfb) from=90m to=100m
.meas tran vfb_50ma avg V(vfb) from=140m to=150m
.meas tran gate_10ma avg V(gate) from=90m to=100m
.meas tran gate_50ma avg V(gate) from=140m to=150m

.control
run
quit
.endc
.end

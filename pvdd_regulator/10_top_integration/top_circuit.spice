* top_circuit.spice — Common top-level flat wiring for all testbenches
*
* This file includes pdk_header.spice and wires all blocks.
* Each testbench only needs to: .include "top_circuit.spice"
* then add stimuli, analysis, and measurements.

.include "pdk_header.spice"

* ============================================================
* Block instantiation — flat wiring
* ============================================================
XM_pass gate bvdd pvdd pass_device
XEA avbg vfb ea_out pvdd 0 ibias ea_en error_amp
XFB pvdd vfb 0 feedback_network
XCOMP ea_out pvdd 0 compensation
XILIM gate bvdd pvdd 0 ilim_flag current_limiter
XUV pvdd avbg uv_flag svdd 0 uvov_en uv_comparator
XOV pvdd avbg ov_flag svdd 0 uvov_en ov_comparator
XZC pvdd 0 zener_clamp
XMC bvdd pvdd svdd 0 avbg en_ret bypass_en mc_ea_en ref_sel uvov_en ilim_en pass_off mode_control
XSU bvdd pvdd gate 0 avbg startup_done ea_en ea_out startup
XLS_EN en en_bvdd bvdd svdd 0 level_shifter_up
Cint pvdd 0 200e-12

* ============================================================
* Standard stimuli (testbenches can override with .alter)
* ============================================================
Vavbg avbg 0 1.226
Ibias ibias 0 DC 1u
Vsvdd svdd 0 2.2
Ven en 0 PWL(0 0 0.5u 0 1u 2.2)
Ven_ret en_ret 0 0

* ============================================================
* Simulation options
* ============================================================
.option reltol=1e-4 abstol=1e-12 vntol=1e-6
.option method=gear maxord=2
.option itl1=500 itl2=500 itl4=500

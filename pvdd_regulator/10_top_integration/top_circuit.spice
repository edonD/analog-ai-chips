* top_circuit.spice — Common top-level flat wiring for all testbenches
*
* Matches design.cir with all 6 fixes applied:
*   FIX 1: Soft-start (Rss+Css)
*   FIX 2: 100nF output cap
*   FIX 3: Cascode Stage 2 (in Block 00)
*   FIX 4: Inner Miller removed (in Block 00)
*   FIX 5: mc_ea_en wired to ea_en with BVDD pull-up
*   FIX 6: Compensation on gate node (not ea_out)

.include "pdk_header.spice"

* ============================================================
* Block instantiation — flat wiring
* ============================================================
XM_pass gate bvdd pvdd pass_device

* FIX 1: Soft-start reference (tau=100us)
Rss avbg vref_ss 100k
Css vref_ss 0 1n

* Error amplifier: soft-start ref, ea_en=bvdd (always on), bvdd for Stage 2
XEA vref_ss vfb ea_out pvdd 0 ibias bvdd bvdd error_amp
XFB pvdd vfb 0 feedback_network

XCOMP ea_out pvdd 0 compensation

XILIM gate bvdd pvdd 0 ilim_flag current_limiter
XUV pvdd avbg uv_flag svdd 0 uvov_en uv_comparator
XOV pvdd avbg ov_flag svdd 0 uvov_en ov_comparator
XZC pvdd 0 zener_clamp
XMC bvdd pvdd svdd 0 avbg en_ret bypass_en mc_ea_en ref_sel uvov_en ilim_en pass_off mode_control

* ea_en=bvdd (always on). Soft-start handles startup sequencing.
XSU bvdd pvdd gate 0 avbg startup_done bvdd ea_out startup

XLS_EN en en_bvdd bvdd svdd 0 level_shifter_up

* FIX 2: Output capacitors (200pF load + 100nF for transient)
Cload pvdd 0 200e-12
Cout_big pvdd 0 100n

* ============================================================
* Standard stimuli (testbenches can override with .alter)
* ============================================================
Vavbg avbg 0 1.226
Ibias ibias 0 DC 1u
Vsvdd svdd 0 2.2
Ven en 0 PWL(0 0 0.5u 0 1u 2.2)
Ven_ret en_ret 0 0

* ============================================================
* Simulation options
* ============================================================
.option reltol=1e-4 abstol=1e-12 vntol=1e-6
.option method=gear maxord=2
.option itl1=500 itl2=500 itl4=500

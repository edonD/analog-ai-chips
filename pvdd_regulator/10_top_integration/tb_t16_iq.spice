* Test 16: Quiescent Current
.title PVDD LDO Quiescent Current Test

.param mc_mm_switch = 0
.param MC_MM_SWITCH = 0
.subckt sky130_fd_pr__model__parasitic__res_po r0 r1 sub w=1 l=1
c0 r0 sub {0.1e-15*w*l}
c1 r1 sub {0.1e-15*w*l}
.ends sky130_fd_pr__model__parasitic__res_po
.lib "../sky130.lib.spice" tt

.include ../00_error_amp/design.cir
.include ../01_pass_device/design.cir
.include ../02_feedback_network/design.cir
.include ../03_compensation/design.cir
.include ../04_current_limiter/design.cir
.include ../05_uv_ov_comparators/design.cir
.include ../06_level_shifter/design.cir
.include ../07_zener_clamp/design.cir
.include ../08_mode_control/design.cir
.include ../09_startup/design.cir
.include design.cir

* Supplies
Vbvdd bvdd 0 7
Vavbg avbg 0 1.226
Iibias 0 ibias 1u
Vsvdd svdd 0 2.2
Ven en 0 2.2
Ven_ret en_ret 0 0

* No load — 10Meg to avoid div-by-zero
Rload pvdd 0 10meg

* DUT
XDUT bvdd pvdd 0 avbg ibias svdd en en_ret uv_flag ov_flag startup_done pvdd_regulator

.option gmin=1e-10 method=gear reltol=1e-3 abstol=1e-10 vntol=1e-4
.op
.control
run
echo "=== TEST 16: QUIESCENT CURRENT ==="
let i_bvdd = -i(Vbvdd)
let i_load = v(pvdd)/10e6
let iq = i_bvdd - i_load
echo "BVDD supply current: $&i_bvdd A"
echo "Load current: $&i_load A"
echo "Quiescent current Iq: $&iq A"
let iq_ua = iq * 1e6
echo "Iq = $&iq_ua uA"
if iq_ua < 300
  echo "PASS: Iq < 300uA"
else
  echo "FAIL: Iq >= 300uA"
end
quit
.endc
.end

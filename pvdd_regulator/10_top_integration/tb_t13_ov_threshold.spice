* Test T13: OV Threshold — measure when ov_flag trips
* Force PVDD externally, sweep 0->7V
* PASS: OV trip between 5.3V and 5.7V
.title PVDD LDO T13 OV Threshold

.param mc_mm_switch = 0
.param MC_MM_SWITCH = 0
.subckt sky130_fd_pr__model__parasitic__res_po r0 r1 sub w=1 l=1
c0 r0 sub {0.1e-15*w*l}
c1 r1 sub {0.1e-15*w*l}
.ends sky130_fd_pr__model__parasitic__res_po
.lib "../sky130.lib.spice" tt

* Only OV comparator block
.include ../05_uv_ov_comparators/design.cir

* Force PVDD externally with ramp 0->7V
Vpvdd pvdd 0 PWL(0 0 100m 7)
Vref vref 0 1.226
Vsvdd svdd 0 2.2
Ven en 0 2.2

* OV comparator
XOV pvdd vref ov_flag svdd 0 en ov_comparator

.option gmin=1e-10 method=gear reltol=1e-3 abstol=1e-10 vntol=1e-4

.tran 10u 100m

.control
run
echo "=== TEST T13: OV THRESHOLD ==="

* OV flag should assert when PVDD exceeds threshold
meas tran ov_trip_rise WHEN v(ov_flag)=1.1 RISE=1
meas tran ov_trip_fall WHEN v(ov_flag)=1.1 FALL=1

* PVDD = 7V * (t/100ms) = 70*t
let pvdd_at_rise = 70 * ov_trip_rise
let pvdd_at_fall = 70 * ov_trip_fall
echo "OV flag rise crossing at PVDD = $&pvdd_at_rise V"
echo "OV flag fall crossing at PVDD = $&pvdd_at_fall V"

* The OV trip is where the flag asserts (PVDD too high)
* Check rise crossing first (more likely for OV assertion)
if pvdd_at_rise > 4.5
  if pvdd_at_rise < 6.5
    echo "OV trip (rise) at PVDD = $&pvdd_at_rise V"
    if pvdd_at_rise > 5.3
      if pvdd_at_rise < 5.7
        echo "RESULT: PASS (OV trip between 5.3V and 5.7V)"
      else
        echo "RESULT: FAIL (OV trip outside 5.3-5.7V range)"
      end
    else
      echo "RESULT: FAIL (OV trip below 5.3V)"
    end
  end
end

if pvdd_at_fall > 4.5
  if pvdd_at_fall < 6.5
    echo "OV trip (fall) at PVDD = $&pvdd_at_fall V"
    if pvdd_at_fall > 5.3
      if pvdd_at_fall < 5.7
        echo "RESULT: PASS (OV trip between 5.3V and 5.7V)"
      else
        echo "RESULT: FAIL (OV trip outside 5.3-5.7V range)"
      end
    else
      echo "RESULT: FAIL (OV trip below 5.3V)"
    end
  end
end

quit
.endc
.end

* Test B: Load transient — ss 27C
.title PVT_B_ss_27

.param mc_mm_switch = 0
.param MC_MM_SWITCH = 0
.subckt sky130_fd_pr__model__parasitic__res_po r0 r1 sub w=1 l=1
c0 r0 sub {0.1e-15*w*l}
c1 r1 sub {0.1e-15*w*l}
.ends sky130_fd_pr__model__parasitic__res_po
.lib "../sky130.lib.spice" ss
.temp 27

.include ../00_error_amp/design.cir
.include ../01_pass_device/design.cir
.include ../02_feedback_network/design.cir
.include ../03_compensation/design.cir
.include ../04_current_limiter/design.cir
.include ../05_uv_ov_comparators/design.cir
.include ../06_level_shifter/design.cir
.include ../07_zener_clamp/design.cir
.include ../08_mode_control/design.cir
.include ../09_startup/design.cir
.include design.cir

* Supplies
Vbvdd bvdd 0 PWL(0 0 10u 7 100m 7)
Ven en 0 PWL(0 0 0.5u 0 1u 2.2)
Vavbg avbg 0 1.226
Iibias 0 ibias 1u
Vsvdd svdd 0 2.2
Ven_ret en_ret 0 0

* Load: current step from 1mA to 10mA at 10ms
Iload pvdd 0 PWL(0 1m 10m 1m 10.001m 10m 20m 10m)

* DUT
XDUT bvdd pvdd 0 avbg ibias svdd en en_ret uv_flag ov_flag startup_done pvdd_regulator

.option gmin=1e-10 method=gear reltol=1e-3 abstol=1e-10 vntol=1e-4
.ic V(pvdd)=0 V(bvdd)=0
.tran 2u 20m uic

.control
run
* Steady state before step: sample at ~9.5ms (index ~4750 out of 10000)
let n = length(v(pvdd))
let idx_pre = n * 48 / 100
let pvdd_pre = v(pvdd)[idx_pre]
* Min PVDD in second half (after step)
let half = n / 2
let pvdd_post_vec = v(pvdd)[half]
let pvdd_min = vecmin(v(pvdd))
echo "RESULT_B_PRE ss 27 ="
print pvdd_pre
echo "RESULT_B_MIN ss 27 ="
print pvdd_min
quit
.endc
.end

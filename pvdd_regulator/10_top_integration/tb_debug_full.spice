* tb_debug_full.spice — Full integration debug
* Same as tb_top_dc_reg but with more node probes and longer run

.param mc_mm_switch = 0
.param MC_MM_SWITCH = 0
.subckt sky130_fd_pr__model__parasitic__res_po r0 r1 sub w=1 l=1
c0 r0 sub {0.1e-15*w*l}
c1 r1 sub {0.1e-15*w*l}
.ends sky130_fd_pr__model__parasitic__res_po
.lib "../sky130.lib.spice" tt
.include "/home/ubuntu/.volare/volare/sky130/versions/0fe599b2afb6708d281543108caf8310912f54af/sky130A/libs.tech/ngspice/parameters/invariant.spice"
.include "/home/ubuntu/.volare/volare/sky130/versions/0fe599b2afb6708d281543108caf8310912f54af/sky130A/libs.ref/sky130_fd_pr/spice/sky130_fd_pr__nfet_01v8__tt.pm3.spice"
.include "/home/ubuntu/.volare/volare/sky130/versions/0fe599b2afb6708d281543108caf8310912f54af/sky130A/libs.ref/sky130_fd_pr/spice/sky130_fd_pr__pfet_01v8__tt.corner.spice"

.include ../00_error_amp/design.cir
.include ../01_pass_device/design.cir
.include ../02_feedback_network/design.cir
.include ../03_compensation/design.cir
.include ../04_current_limiter/design.cir
.include ../05_uv_ov_comparators/design.cir
.include ../06_level_shifter/design.cir
.include ../07_zener_clamp/design.cir
.include ../08_mode_control/design.cir
.include ../09_startup/design.cir

* ============================================================
* Full integration — flat wiring
* ============================================================
XM_pass gate bvdd pvdd pass_device
XEA avbg vfb ea_out pvdd 0 ibias ea_en error_amp
XFB pvdd vfb 0 feedback_network
XCOMP ea_out pvdd 0 compensation
XILIM gate bvdd pvdd 0 ilim_flag current_limiter
XUV pvdd avbg uv_flag svdd 0 uvov_en uv_comparator
XOV pvdd avbg ov_flag svdd 0 uvov_en ov_comparator
XZC pvdd 0 zener_clamp
XMC bvdd pvdd svdd 0 en_ret bypass_en mc_ea_en ref_sel uvov_en ilim_en pass_off mode_control
XSU bvdd pvdd gate 0 avbg startup_done ea_en ea_out startup
XLS_EN en en_bvdd bvdd svdd 0 level_shifter_up
Cint pvdd 0 200e-12

* ============================================================
* Stimuli — BVDD step to 7V (fast), constant 10mA load
* ============================================================
Vbvdd bvdd 0 PWL(0 0 10u 7 100m 7)
Vavbg avbg 0 1.226
Ibias ibias 0 DC 1u
Vsvdd svdd 0 2.2
Ven en 0 PWL(0 0 0.5u 0 1u 2.2)
Ven_ret en_ret 0 0
Rload pvdd 0 500
Cout pvdd 0 1u

.option reltol=1e-4 abstol=1e-12 vntol=1e-6
.option method=gear maxord=2
.option itl1=500 itl2=500 itl4=500

.ic V(pvdd)=0 V(bvdd)=0

* Run for 50ms — startup RC delay tau=2.4ms, need ~12ms (5*tau)
.tran 5u 50m uic

* Late measurements (well after startup RC)
.meas tran vpvdd_ss avg V(pvdd) from=40m to=50m
.meas tran vea_out_ss avg V(ea_out) from=40m to=50m
.meas tran vfb_ss avg V(vfb) from=40m to=50m
.meas tran vgate_ss avg V(gate) from=40m to=50m
.meas tran vea_en_ss avg V(ea_en) from=40m to=50m

* Startup circuit internal nodes
.meas tran vls_bias avg V(xsu.ls_bias) from=40m to=50m
.meas tran vdet_out avg V(xsu.det_out) from=40m to=50m
.meas tran vinv_det avg V(xsu.inv_det) from=40m to=50m

.control
run

echo "=== Full Integration Debug (t=40-50ms) ==="
echo "pvdd: $&vpvdd_ss"
echo "ea_out: $&vea_out_ss"
echo "vfb: $&vfb_ss"
echo "gate: $&vgate_ss"
echo "ea_en: $&vea_en_ss"
echo "ls_bias: $&vls_bias"
echo "det_out: $&vdet_out"
echo "inv_det: $&vinv_det"

quit
.endc

.end

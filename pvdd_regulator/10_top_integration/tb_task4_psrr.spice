* Task 4: PSRR Measurement — PVDD Regulator
* AC analysis: inject AC on BVDD, measure at PVDD
* PSRR = db(V(pvdd)/V(bvdd)) = db(V(pvdd)) since Vac=1

* === PDK Setup ===
.param mc_mm_switch = 0
.param MC_MM_SWITCH = 0
.subckt sky130_fd_pr__model__parasitic__res_po r0 r1 sub w=1 l=1
c0 r0 sub {0.1e-15*w*l}
c1 r1 sub {0.1e-15*w*l}
.ends sky130_fd_pr__model__parasitic__res_po
.lib "../sky130.lib.spice" tt

* === Block includes ===
.include ../00_error_amp/design.cir
.include ../01_pass_device/design.cir
.include ../02_feedback_network/design.cir
.include ../03_compensation/design.cir
.include ../04_current_limiter/design.cir
.include ../05_uv_ov_comparators/design.cir
.include ../06_level_shifter/design.cir
.include ../07_zener_clamp/design.cir
.include ../08_mode_control/design.cir
.include ../09_startup/design.cir
.include design.cir

* === Supplies ===
Vbvdd bvdd 0 dc 7 ac 1
Vavbg avbg 0 1.226
Iibias 0 ibias 1u
Vsvdd svdd 0 2.2
Ven en 0 2.2
Ven_ret en_ret 0 0
Rload pvdd 0 700

* === DUT ===
XDUT bvdd pvdd 0 avbg ibias svdd en en_ret uv_flag ov_flag startup_done pvdd_regulator

* === Options ===
.option gmin=1e-10 method=gear reltol=1e-3 abstol=1e-10 vntol=1e-4

* === Nodeset for convergence ===
.nodeset v(pvdd)=5.0

* === AC Analysis ===
.ac dec 50 1 10meg

.control
run

* PSRR = db(V(pvdd)) since Vac on bvdd = 1V
let psrr = db(v(pvdd))

* Print PSRR at key frequencies
print psrr[0]

* Find PSRR at specific frequencies using meas
meas ac psrr_dc find vdb(pvdd) at=1
meas ac psrr_1k find vdb(pvdd) at=1000
meas ac psrr_10k find vdb(pvdd) at=10000
meas ac psrr_100k find vdb(pvdd) at=100000
meas ac psrr_1m find vdb(pvdd) at=1e6

echo "=== PSRR SUMMARY ==="
echo "PSRR_DC (1Hz):   $&psrr_dc dB"
echo "PSRR_1kHz:       $&psrr_1k dB"
echo "PSRR_10kHz:      $&psrr_10k dB"
echo "PSRR_100kHz:     $&psrr_100k dB"
echo "PSRR_1MHz:       $&psrr_1m dB"
echo "=== PASS CRITERIA ==="
echo "PSRR_DC < -40dB (>40dB rejection): check $&psrr_dc"
echo "PSRR_10kHz < -20dB (>20dB rejection): check $&psrr_10k"

.endc
.end

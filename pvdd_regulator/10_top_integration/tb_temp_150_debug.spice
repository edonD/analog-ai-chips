* Task 1: DC operating point check — 150C debug (no current limiter clamp)
.title PVDD LDO DC Check 150C debug

.param mc_mm_switch = 0
.param MC_MM_SWITCH = 0
.subckt sky130_fd_pr__model__parasitic__res_po r0 r1 sub w=1 l=1
c0 r0 sub {0.1e-15*w*l}
c1 r1 sub {0.1e-15*w*l}
.ends sky130_fd_pr__model__parasitic__res_po
.lib "../sky130.lib.spice" tt

.include ../00_error_amp/design.cir
.include ../01_pass_device/design.cir
.include ../02_feedback_network/design.cir
.include ../03_compensation/design.cir
.include ../04_current_limiter/design.cir
.include ../05_uv_ov_comparators/design.cir
.include ../06_level_shifter/design.cir
.include ../07_zener_clamp/design.cir
.include ../08_mode_control/design.cir
.include ../09_startup/design.cir
.include design.cir

* Supplies
Vbvdd bvdd 0 7
Vavbg avbg 0 1.226
Iibias 0 ibias 1u
Vsvdd svdd 0 2.2
Ven en 0 2.2
Ven_ret en_ret 0 0

* Load: 1mA
Rload pvdd 0 5000

* DUT
XDUT bvdd pvdd 0 avbg ibias svdd en en_ret uv_flag ov_flag startup_done pvdd_regulator

.option temp=150
.option gmin=1e-10 method=gear reltol=1e-3 abstol=1e-10 vntol=1e-4
.op
.control
op
echo "=== 150C DEBUG ==="
print v(pvdd) v(xdut.gate) v(xdut.ea_out)
print v(xdut.xilim.sense_n) v(xdut.xilim.det_n)
* Check leakage: what's the current through pull-up vs detection NMOS
print @m.xdut.xilim.xmdet.msky130_fd_pr__nfet_g5v0d10v5[id]
print @m.xdut.xilim.xmdet.msky130_fd_pr__nfet_g5v0d10v5[vgs]
print @m.xdut.xilim.xmdet.msky130_fd_pr__nfet_g5v0d10v5[vth]
quit
.endc
.end

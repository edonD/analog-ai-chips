* Plot 17: UV/OV — sweep PVDD externally, monitor flags
.title UV/OV Characterization

.param mc_mm_switch = 0
.param MC_MM_SWITCH = 0
.subckt sky130_fd_pr__model__parasitic__res_po r0 r1 sub w=1 l=1
c0 r0 sub {0.1e-15*w*l}
c1 r1 sub {0.1e-15*w*l}
.ends sky130_fd_pr__model__parasitic__res_po
.lib "../sky130.lib.spice" tt
.temp 27

.include ../05_uv_ov_comparators/design.cir

Vsvdd svdd 0 2.2
Vavbg avbg 0 1.226
Ven uvov_en 0 2.2

* Sweep PVDD: 0→6V→0V triangle
Vpvdd pvdd 0 PWL(0 0 6m 6 12m 0)

XUV pvdd avbg uv_flag svdd 0 uvov_en uv_comparator
XOV pvdd avbg ov_flag svdd 0 uvov_en ov_comparator

.tran 1u 12m

.control
run
set filetype = ascii
wrdata plt17_pvdd.dat v(pvdd)
wrdata plt17_uv.dat v(uv_flag)
wrdata plt17_ov.dat v(ov_flag)
echo "UV/OV done"
quit
.endc
.end

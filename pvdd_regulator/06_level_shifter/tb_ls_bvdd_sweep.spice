* tb_ls_bvdd_sweep.spice — Functionality across BVDD range
* Block 06: Level Shifter — TT 27C
* Tests at BVDD = 5.4V, 7V, 10.5V sequentially
*
.include design.cir
.lib /home/ubuntu/pdk/volare/sky130/versions/0fe599b2afb6708d281543108caf8310912f54af/sky130A/libs.tech/ngspice/sky130.lib.spice tt

.option method=gear reltol=1e-4

.param bvdd_val=5.4

* Supplies
Vsvdd svdd 0 2.2
Vbvdd bvdd 0 {bvdd_val}
Vpvdd pvdd 0 5.0

* Load
Cload_up out_up 0 1p
Cload_dn out_dn 0 1p

* Input
Vin_up in_up 0 PULSE(0 2.2 50n 1n 1n 200n 400n)
Vin_dn in_dn 0 PULSE(0 5.0 50n 1n 1n 200n 400n)

* DUT
Xup in_up out_up bvdd svdd 0 level_shifter_up
Xdn in_dn out_dn pvdd svdd 0 level_shifter_down

.tran 0.1n 800n

.control

* === BVDD = 5.4V ===
alterparam bvdd_val = 5.4
reset
run
meas tran up_high_54 MAX v(out_up) FROM=100n TO=250n
meas tran up_low_54  MIN v(out_up) FROM=300n TO=450n
echo "=== BVDD=5.4V ==="
echo "up_out_high_54:" "$&up_high_54"
echo "up_out_low_54:" "$&up_low_54"
let w54 = 1
if up_high_54 < 5.2
  let w54 = 0
end
if up_low_54 > 0.2
  let w54 = 0
end
echo "works_bvdd_min:" "$&w54"

* === BVDD = 7.0V ===
alterparam bvdd_val = 7.0
reset
run
meas tran up_high_70 MAX v(out_up) FROM=100n TO=250n
meas tran up_low_70  MIN v(out_up) FROM=300n TO=450n
echo "=== BVDD=7.0V ==="
echo "up_out_high_70:" "$&up_high_70"
echo "up_out_low_70:" "$&up_low_70"

* === BVDD = 10.5V ===
alterparam bvdd_val = 10.5
reset
run
meas tran up_high_105 MAX v(out_up) FROM=100n TO=250n
meas tran up_low_105  MIN v(out_up) FROM=300n TO=450n
echo "=== BVDD=10.5V ==="
echo "up_out_high_105:" "$&up_high_105"
echo "up_out_low_105:" "$&up_low_105"
let w105 = 1
if up_high_105 < 10.3
  let w105 = 0
end
if up_low_105 > 0.2
  let w105 = 0
end
echo "works_bvdd_max:" "$&w105"

quit
.endc

.end

* tb_ls_bvdd_sweep.spice — Functionality across BVDD range
* Block 06: Level Shifter — TT 27C
* Tests at BVDD = 5.4V, 7V, 10.5V sequentially
*
.include design.cir
.lib /home/ubuntu/pdk/volare/sky130/versions/0fe599b2afb6708d281543108caf8310912f54af/sky130A/libs.tech/ngspice/sky130.lib.spice tt

.option method=gear reltol=1e-4

.param bvdd_val=5.4

* Supplies
Vsvdd svdd 0 2.2
Vbvdd bvdd 0 {bvdd_val}
Vpvdd pvdd 0 5.0

* Load
Cload_up out_up 0 1p
Cload_dn out_dn 0 1p

* Input
Vin_up in_up 0 PULSE(0 2.2 50n 1n 1n 200n 400n)
Vin_dn in_dn 0 PULSE(0 5.0 50n 1n 1n 200n 400n)

* DUT
Xup in_up out_up bvdd svdd 0 level_shifter_up
Xdn in_dn out_dn pvdd svdd 0 level_shifter_down

.tran 0.1n 800n

.meas tran up_out_high MAX v(out_up) FROM=100n TO=250n
.meas tran up_out_low  MIN v(out_up) FROM=300n TO=450n
.meas tran tplh_up TRIG v(in_up) VAL=1.1 RISE=1 TARG v(out_up) VAL='bvdd_val/2' RISE=1
.meas tran tphl_up TRIG v(in_up) VAL=1.1 FALL=1 TARG v(out_up) VAL='bvdd_val/2' FALL=1

.control

* === BVDD = 5.4V ===
alterparam bvdd_val = 5.4
reset
run
echo "=== BVDD=5.4V ==="
echo "up_out_high_54:" "$&up_out_high"
echo "up_out_low_54:" "$&up_out_low"
let margin_54 = up_out_high - 5.2
let ok_h = (up_out_high > 5.2)
let ok_l = (up_out_low < 0.2)
let works_54 = ok_h & ok_l
echo "works_bvdd_min:" "$&works_54"

* === BVDD = 7.0V ===
alterparam bvdd_val = 7.0
reset
run
echo "=== BVDD=7.0V ==="
echo "up_out_high_70:" "$&up_out_high"
echo "up_out_low_70:" "$&up_out_low"

* === BVDD = 10.5V ===
alterparam bvdd_val = 10.5
reset
run
echo "=== BVDD=10.5V ==="
echo "up_out_high_105:" "$&up_out_high"
echo "up_out_low_105:" "$&up_out_low"
let margin_105 = up_out_high - 10.3
let ok_h2 = (up_out_high > 10.3)
let ok_l2 = (up_out_low < 0.2)
let works_105 = ok_h2 & ok_l2
echo "works_bvdd_max:" "$&works_105"

quit
.endc

.end

* Block 06: Level Shifters
* PVDD 5V LDO Regulator — SkyWater SKY130A
*
* Two subcircuits:
*   1. level_shifter_up   — SVDD (2.2V) → BVDD (5.4–10.5V)
*   2. level_shifter_down — PVDD (5.0V) → SVDD (2.2V)
*
* Both use cross-coupled PMOS topology for zero static current.
* All devices are HV (g5v0d10v5).
* All W/L in METERS (no SCALE, no ngbehavior=hs required).
*
* ============================================================
* Low-to-High Shifter: SVDD → BVDD
* ============================================================
.subckt level_shifter_up in out bvdd svdd gnd

* Input inverter (SVDD domain)
XMN_INV in_b in  gnd  gnd  sky130_fd_pr__nfet_g5v0d10v5 W=2e-6 L=0.5e-6
XMP_INV in_b in  svdd svdd sky130_fd_pr__pfet_g5v0d10v5 W=4e-6 L=0.5e-6

* NMOS pull-downs (driven by SVDD-level signals, L=1u to reduce subthreshold leakage)
XMN1 n1  in   gnd gnd sky130_fd_pr__nfet_g5v0d10v5 W=15e-6 L=1e-6
XMN2 out in_b gnd gnd sky130_fd_pr__nfet_g5v0d10v5 W=15e-6 L=1e-6

* Cross-coupled PMOS (BVDD domain) — asymmetric: XMP2 wider for lower Ron on output
XMP1 n1  out bvdd bvdd sky130_fd_pr__pfet_g5v0d10v5 W=4e-6  L=0.5e-6
XMP2 out n1  bvdd bvdd sky130_fd_pr__pfet_g5v0d10v5 W=5e-6  L=0.5e-6

.ends level_shifter_up

* ============================================================
* High-to-Low Shifter: PVDD → SVDD
* ============================================================
.subckt level_shifter_down in out pvdd svdd gnd

* Input inverter (PVDD domain)
XMN_INV in_b in  gnd  gnd  sky130_fd_pr__nfet_g5v0d10v5 W=2e-6 L=0.5e-6
XMP_INV in_b in  pvdd pvdd sky130_fd_pr__pfet_g5v0d10v5 W=4e-6 L=0.5e-6

* NMOS pull-downs (driven by PVDD-level signals, L=1u to reduce subthreshold leakage)
XMN1 n1  in   gnd gnd sky130_fd_pr__nfet_g5v0d10v5 W=2e-6 L=1e-6
XMN2 out in_b gnd gnd sky130_fd_pr__nfet_g5v0d10v5 W=2e-6 L=1e-6

* Cross-coupled PMOS (SVDD domain)
XMP1 n1  out svdd svdd sky130_fd_pr__pfet_g5v0d10v5 W=4e-6 L=0.5e-6
XMP2 out n1  svdd svdd sky130_fd_pr__pfet_g5v0d10v5 W=4e-6 L=0.5e-6

.ends level_shifter_down

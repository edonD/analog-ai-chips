* tb_pass_pvt.spice — PVT corners (TT only, calls SS/FF sub-files)
.lib "/home/ubuntu/pdk/sky130A/libs.ref/sky130_fd_pr/spice/sky130_pfet_g5v0d10v5_only.lib.spice" tt
.include "design.cir"

Vbvdd bvdd 0 5.4
Vdrain pvdd 0 5.0
Vgate gate 0 0

X1 gate bvdd pvdd pass_device

.control
* TT -40C
set temp = -40
op
let id_ma = abs(i(Vdrain)) * 1000
echo pvt_id_tt_m40_mA: $&id_ma

* TT 27C
reset
set temp = 27
op
let id_ma = abs(i(Vdrain)) * 1000
echo pvt_id_tt27_mA: $&id_ma

* TT 150C
reset
set temp = 150
op
let id_ma = abs(i(Vdrain)) * 1000
echo pvt_id_tt150_mA: $&id_ma

* Run SS and FF corners
shell ngspice -b tb_pass_pvt_ss.spice
shell ngspice -b tb_pass_pvt_ff.spice

quit
.endc
.end

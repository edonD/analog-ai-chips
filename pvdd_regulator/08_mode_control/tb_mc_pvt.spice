* Testbench: Mode Control — PVT (all 5 corners)
* Delegates to run_pvt.py which generates and runs per-corner netlists
V1 dummy 0 0
.control
shell python3 run_pvt.py
.endc
.end

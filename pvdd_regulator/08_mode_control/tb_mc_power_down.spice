* Testbench: Mode Control — Power Down (BVDD 10.5V to 0V at 1V/us)
* Verifies reverse transition order during power-down
.include "parasitic_res_po.spice"
.lib "../sky130.lib.spice" tt
.include "design.cir"
.option method=gear reltol=1e-3 abstol=1e-12 vntol=1e-6 gmin=1e-12
.option itl1=300 itl2=200 itl4=50
Vbvdd bvdd gnd PWL(0 10.5 10.5u 0)
Vpvdd pvdd gnd 5.0
Vsvdd svdd gnd 2.2
Vref  vref gnd 1.226
Ven   en_ret gnd 0
XDUT bvdd pvdd svdd gnd vref en_ret bypass_en ea_en ref_sel uvov_en ilim_en pass_off mode_control
.tran 10n 12u
.control
save all
run
* Measure falling thresholds: when each comparator output falls during power-down
* comp4 falls first (highest BVDD threshold), then comp3, comp2, comp1
meas tran th4f FIND v(bvdd) WHEN v(xdut.comp4)=2.5 FALL=1
meas tran th3f FIND v(bvdd) WHEN v(xdut.comp3)=2.5 FALL=1
meas tran th2f FIND v(bvdd) WHEN v(xdut.comp2)=2.5 FALL=1
meas tran th1f FIND v(bvdd) WHEN v(xdut.comp1)=2.5 FALL=1
* Reverse order means: th4f > th3f > th2f > th1f (higher BVDD = deasserts first)
let ok = 1
if th4f <= th3f
  let ok = 0
end
if th3f <= th2f
  let ok = 0
end
if th2f <= th1f
  let ok = 0
end
echo "power_down_correct: $&ok"
.endc
.end

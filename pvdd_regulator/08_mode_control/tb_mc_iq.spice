* Testbench: Mode Control — Quiescent Current
.include "parasitic_res_po.spice"
.lib "../sky130.lib.spice" tt
.include "design.cir"
.option method=gear reltol=1e-3 abstol=1e-12 vntol=1e-6 gmin=1e-12
.option itl1=300 itl2=200 itl4=50
* Ramp to 7V quickly, then hold for 10µs to let everything settle
Vbvdd bvdd gnd PWL(0 0 0.1u 7 15u 7)
Vpvdd pvdd gnd 5.0
Vsvdd svdd gnd 2.2
Vref  vref gnd 1.226
Ven   en_ret gnd 0
XDUT bvdd pvdd svdd gnd vref en_ret bypass_en ea_en ref_sel uvov_en ilim_en pass_off mode_control
.tran 10n 15u uic
.control
run
* Measure steady-state Iq after settling (t=10-14µs)
meas tran iq_val AVG i(vbvdd) FROM=10u TO=14u
let iq_ua = abs(iq_val) * 1e6
echo "iq_active_uA: $&iq_ua"
.endc
.end

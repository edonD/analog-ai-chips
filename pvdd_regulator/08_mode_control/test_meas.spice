* Meas test with TD
.include "parasitic_res_po.spice"
.lib "../sky130.lib.spice" tt
.include "design.cir"
.option method=gear reltol=1e-3 abstol=1e-12 vntol=1e-6 gmin=1e-12
Vbvdd bvdd gnd PWL(0 0 10.5u 10.5)
Vpvdd pvdd gnd 5.0
Vsvdd svdd gnd 2.2
Vref  vref gnd 1.226
Ven   en_ret gnd 0
XDUT bvdd pvdd svdd gnd vref en_ret bypass_en ea_en ref_sel uvov_en ilim_en pass_off mode_control
.tran 10n 12u uic
.control
run
meas tran t_bp1 WHEN v(bypass_en)=0.5 RISE=1 TD=2u
meas tran bv_bp1 FIND v(bvdd) WHEN v(bypass_en)=0.5 RISE=1 TD=2u
echo "bypass_en first rise: t=$&t_bp1, BVDD=$&bv_bp1"
meas tran bv_ea1 FIND v(bvdd) WHEN v(ea_en)=0.5 RISE=1 TD=2u
echo "ea_en first rise: BVDD=$&bv_ea1"
meas tran bv_bp2 FIND v(bvdd) WHEN v(bypass_en)=0.5 RISE=2 TD=2u
echo "bypass_en second rise: BVDD=$&bv_bp2"
meas tran bv_uv1 FIND v(bvdd) WHEN v(uvov_en)=0.5 RISE=1 TD=2u
echo "uvov_en first rise: BVDD=$&bv_uv1"
.endc
.end

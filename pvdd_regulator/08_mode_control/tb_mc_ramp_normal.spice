* Testbench: Mode Control — Normal Ramp (1 V/µs)
.include "parasitic_res_po.spice"
.lib "../sky130.lib.spice" tt
.include "design.cir"
.option method=gear reltol=1e-3 abstol=1e-12 vntol=1e-6 gmin=1e-12
.option itl1=300 itl2=200 itl4=50
Vbvdd bvdd gnd PWL(0 0 10.5u 10.5)
Vpvdd pvdd gnd 5.0
Vsvdd svdd gnd 2.2
Vref  vref gnd 1.226
Ven   en_ret gnd 0
XDUT bvdd pvdd svdd gnd vref en_ret bypass_en ea_en ref_sel uvov_en ilim_en pass_off mode_control
.tran 10n 12u uic
.control
run
set wr_singlescale
set wr_vecnames
wrdata ramp_normal.txt v(bvdd) v(bypass_en) v(ea_en) v(ref_sel) v(uvov_en) v(ilim_en) v(pass_off)
meas tran thresh_por_v FIND v(bvdd) WHEN v(bypass_en)=0.5 RISE=1 TD=2u
meas tran thresh_ret_v FIND v(bvdd) WHEN v(ea_en)=0.5 RISE=1 TD=2u
meas tran thresh_pup_v FIND v(bvdd) WHEN v(bypass_en)=0.5 RISE=2 TD=2u
meas tran thresh_act_v FIND v(bvdd) WHEN v(uvov_en)=0.5 RISE=1 TD=2u
let e1 = abs(thresh_por_v - 2.5)/2.5*100
let e2 = abs(thresh_ret_v - 4.2)/4.2*100
let e3 = abs(thresh_pup_v - 4.5)/4.5*100
let e4 = abs(thresh_act_v - 5.6)/5.6*100
let max_err = e1
if e2 > max_err
  let max_err = e2
end
if e3 > max_err
  let max_err = e3
end
if e4 > max_err
  let max_err = e4
end
let mono = 1
if thresh_por_v >= thresh_ret_v
  let mono = 0
end
if thresh_ret_v >= thresh_pup_v
  let mono = 0
end
if thresh_pup_v >= thresh_act_v
  let mono = 0
end
echo "thresh_por_V: $&thresh_por_v"
echo "thresh_ret_V: $&thresh_ret_v"
echo "thresh_pup_V: $&thresh_pup_v"
echo "thresh_act_V: $&thresh_act_v"
echo "thresh_max_error_pct: $&max_err"
echo "monotonic: $&mono"
* Glitch detection: check for extra crossings beyond expected count
* bypass_en: expected 2 rising edges (at TH1 and TH3)
meas tran g_by3 FIND v(bvdd) WHEN v(bypass_en)=2.5 RISE=3 TD=2u
* ea_en: expected 2 rising edges (at TH2 and TH4)
meas tran g_ea3 FIND v(bvdd) WHEN v(ea_en)=2.5 RISE=3 TD=2u
* ref_sel: expected 1 rising edge (at TH1)
meas tran g_rs2 FIND v(bvdd) WHEN v(ref_sel)=2.5 RISE=2 TD=2u
* uvov_en: expected 1 rising edge (at TH4)
meas tran g_uv2 FIND v(bvdd) WHEN v(uvov_en)=2.5 RISE=2 TD=2u
* pass_off: expected 1 falling edge (at TH1)
meas tran g_po2 FIND v(bvdd) WHEN v(pass_off)=2.5 FALL=2 TD=2u
let gf = 1
if g_by3 > 0.1
  let gf = 0
end
if g_ea3 > 0.1
  let gf = 0
end
if g_rs2 > 0.1
  let gf = 0
end
if g_uv2 > 0.1
  let gf = 0
end
if g_po2 > 0.1
  let gf = 0
end
echo "glitch_free: $&gf"
.endc
.end

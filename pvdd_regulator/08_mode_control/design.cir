* Block 08: Mode Control — v8 (PMOS diff pair, PVDD-powered)
* PVDD 5V LDO Regulator — SkyWater SKY130A
*
* PMOS diff pair from PVDD: Vsg = tail-input ≈ 3.8V >> |Vthp|=1.01V
* NMOS mirror load. PMOS tail biased from PVDD.
* Config A + 2 inverters: co rises when tap>vref, comp=HIGH ✓
* Startup (tap=0): co drops → comp=LOW ✓
*
.subckt mode_control bvdd pvdd svdd gnd vref en_ret bypass_en ea_en ref_sel uvov_en ilim_en pass_off

* =============================================
* RESISTOR LADDER (from BVDD)
* =============================================
.param rtop_l = 241
.param r12_l  = 94
.param r23_l  = 9.2
.param r34_l  = 25
.param rbot_l = 103

XRtop bvdd tap1 gnd sky130_fd_pr__res_xhigh_po w=1 l=rtop_l
XR12  tap1 tap2 gnd sky130_fd_pr__res_xhigh_po w=1 l=r12_l
XR23  tap2 tap3 gnd sky130_fd_pr__res_xhigh_po w=1 l=r23_l
XR34  tap3 tap4 gnd sky130_fd_pr__res_xhigh_po w=1 l=r34_l
XRbot tap4 gnd  gnd sky130_fd_pr__res_xhigh_po w=1 l=rbot_l
C_tap1 tap1 gnd 100f
C_tap2 tap2 gnd 100f
C_tap3 tap3 gnd 100f
C_tap4 tap4 gnd 100f

* =============================================
* PMOS TAIL BIAS (from PVDD)
* =============================================
* Diode PMOS (PVDD→pbias) + Rbias to GND sets pbias voltage (~3.2V for ~10µA)
XMpbias pbias pbias pvdd pvdd sky130_fd_pr__pfet_g5v0d10v5 w=20e-6 l=20e-6
XRpbias pbias gnd gnd sky130_fd_pr__res_xhigh_po w=1 l=30

* =============================================
* COMPARATOR 1: tap1 vs vref — TH1 = 2.5V
* =============================================
* Uses CMOS inverter threshold detector (fast, no OTA slew limit)
* Separate voltage divider from BVDD sets the tap ratio
* Inverter from PVDD: trip at ~1.4V. Divider ratio = 1.4/2.5 = 0.56
* PFET W=20 (min), NFET W=60 → lower trip point
* Divider: ratio=0.82, Rtotal~300kΩ for faster RC response
* At BVDD=2.5V: c1tap_ss = 2.5*0.82 = 2.05V → above trip ~1.82V
XRc1top bvdd c1tap gnd sky130_fd_pr__res_xhigh_po w=1 l=20
XRc1bot c1tap gnd  gnd sky130_fd_pr__res_xhigh_po w=1 l=130
C_c1tap c1tap gnd 50f
* Inverter from PVDD: W_p=W_n=20µm → trip ~1.82V
XMc1ivp c1inv c1tap pvdd pvdd sky130_fd_pr__pfet_g5v0d10v5 w=20e-6 l=20e-6
XMc1ivn c1inv c1tap gnd  gnd  sky130_fd_pr__nfet_g5v0d10v5 w=20e-6 l=20e-6
* Second inverter to restore polarity: comp1 = HIGH when c1tap > trip
XMc1iv2p comp1 c1inv pvdd pvdd sky130_fd_pr__pfet_g5v0d10v5 w=40e-6 l=20e-6
XMc1iv2n comp1 c1inv gnd  gnd  sky130_fd_pr__nfet_g5v0d10v5 w=20e-6 l=20e-6

* =============================================
* COMPARATOR 2: tap2 vs vref — TH2 = 4.2V
* =============================================
XM2pt c2tail pbias pvdd pvdd sky130_fd_pr__pfet_g5v0d10v5 w=20e-6 l=20e-6
XM2p1 c2mi tap2 c2tail c2tail sky130_fd_pr__pfet_g5v0d10v5 w=20e-6 l=20e-6
XM2p2 c2o  vref c2tail c2tail sky130_fd_pr__pfet_g5v0d10v5 w=20e-6 l=20e-6
XM2n3 c2mi c2mi gnd gnd sky130_fd_pr__nfet_g5v0d10v5 w=20e-6 l=20e-6
XM2n4 c2o  c2mi gnd gnd sky130_fd_pr__nfet_g5v0d10v5 w=20e-6 l=20e-6
XM2iv1p c2ob c2o pvdd pvdd sky130_fd_pr__pfet_g5v0d10v5 w=40e-6 l=20e-6
XM2iv1n c2ob c2o gnd  gnd  sky130_fd_pr__nfet_g5v0d10v5 w=20e-6 l=20e-6
XM2iv2p comp2 c2ob pvdd pvdd sky130_fd_pr__pfet_g5v0d10v5 w=40e-6 l=20e-6
XM2iv2n comp2 c2ob gnd  gnd  sky130_fd_pr__nfet_g5v0d10v5 w=20e-6 l=20e-6

* =============================================
* COMPARATOR 3: tap3 vs vref — TH3 = 4.5V
* =============================================
XM3pt c3tail pbias pvdd pvdd sky130_fd_pr__pfet_g5v0d10v5 w=20e-6 l=20e-6
XM3p1 c3mi tap3 c3tail c3tail sky130_fd_pr__pfet_g5v0d10v5 w=20e-6 l=20e-6
XM3p2 c3o  vref c3tail c3tail sky130_fd_pr__pfet_g5v0d10v5 w=20e-6 l=20e-6
XM3n3 c3mi c3mi gnd gnd sky130_fd_pr__nfet_g5v0d10v5 w=20e-6 l=20e-6
XM3n4 c3o  c3mi gnd gnd sky130_fd_pr__nfet_g5v0d10v5 w=20e-6 l=20e-6
XM3iv1p c3ob c3o pvdd pvdd sky130_fd_pr__pfet_g5v0d10v5 w=40e-6 l=20e-6
XM3iv1n c3ob c3o gnd  gnd  sky130_fd_pr__nfet_g5v0d10v5 w=20e-6 l=20e-6
XM3iv2p comp3 c3ob pvdd pvdd sky130_fd_pr__pfet_g5v0d10v5 w=40e-6 l=20e-6
XM3iv2n comp3 c3ob gnd  gnd  sky130_fd_pr__nfet_g5v0d10v5 w=20e-6 l=20e-6

* =============================================
* COMPARATOR 4: tap4 vs vref — TH4 = 5.6V
* =============================================
XM4pt c4tail pbias pvdd pvdd sky130_fd_pr__pfet_g5v0d10v5 w=20e-6 l=20e-6
XM4p1 c4mi tap4 c4tail c4tail sky130_fd_pr__pfet_g5v0d10v5 w=20e-6 l=20e-6
XM4p2 c4o  vref c4tail c4tail sky130_fd_pr__pfet_g5v0d10v5 w=20e-6 l=20e-6
XM4n3 c4mi c4mi gnd gnd sky130_fd_pr__nfet_g5v0d10v5 w=20e-6 l=20e-6
XM4n4 c4o  c4mi gnd gnd sky130_fd_pr__nfet_g5v0d10v5 w=20e-6 l=20e-6
XM4iv1p c4ob c4o pvdd pvdd sky130_fd_pr__pfet_g5v0d10v5 w=40e-6 l=20e-6
XM4iv1n c4ob c4o gnd  gnd  sky130_fd_pr__nfet_g5v0d10v5 w=20e-6 l=20e-6
XM4iv2p comp4 c4ob pvdd pvdd sky130_fd_pr__pfet_g5v0d10v5 w=40e-6 l=20e-6
XM4iv2n comp4 c4ob gnd  gnd  sky130_fd_pr__nfet_g5v0d10v5 w=20e-6 l=20e-6

* =============================================
* LOGIC (from BVDD)
* =============================================
XMinv1p comp1b comp1 bvdd bvdd sky130_fd_pr__pfet_g5v0d10v5 w=40e-6 l=20e-6
XMinv1n comp1b comp1 gnd  gnd  sky130_fd_pr__nfet_g5v0d10v5 w=20e-6 l=20e-6
XMinv2p comp2b comp2 bvdd bvdd sky130_fd_pr__pfet_g5v0d10v5 w=40e-6 l=20e-6
XMinv2n comp2b comp2 gnd  gnd  sky130_fd_pr__nfet_g5v0d10v5 w=20e-6 l=20e-6
XMinv3p comp3b comp3 bvdd bvdd sky130_fd_pr__pfet_g5v0d10v5 w=40e-6 l=20e-6
XMinv3n comp3b comp3 gnd  gnd  sky130_fd_pr__nfet_g5v0d10v5 w=20e-6 l=20e-6
XMinv4p comp4b comp4 bvdd bvdd sky130_fd_pr__pfet_g5v0d10v5 w=40e-6 l=20e-6
XMinv4n comp4b comp4 gnd  gnd  sky130_fd_pr__nfet_g5v0d10v5 w=20e-6 l=20e-6

XRpo_pu bvdd pass_off gnd sky130_fd_pr__res_xhigh_po w=1 l=50
XMpo_bufp pass_off comp1b bvdd bvdd sky130_fd_pr__pfet_g5v0d10v5 w=40e-6 l=20e-6
XMpo_bufn pass_off comp1b gnd  gnd  sky130_fd_pr__nfet_g5v0d10v5 w=20e-6 l=20e-6

XMby_n1a by_s1     comp1  gnd gnd sky130_fd_pr__nfet_g5v0d10v5 w=20e-6 l=20e-6
XMby_n1b bypass_enb comp2b by_s1 by_s1 sky130_fd_pr__nfet_g5v0d10v5 w=20e-6 l=20e-6
XMby_n2a by_s2     comp3  gnd gnd sky130_fd_pr__nfet_g5v0d10v5 w=20e-6 l=20e-6
XMby_n2b bypass_enb comp4b by_s2 by_s2 sky130_fd_pr__nfet_g5v0d10v5 w=20e-6 l=20e-6
XMby_p1a by_pmid comp1  bvdd bvdd sky130_fd_pr__pfet_g5v0d10v5 w=40e-6 l=20e-6
XMby_p1b by_pmid comp2b bvdd bvdd sky130_fd_pr__pfet_g5v0d10v5 w=40e-6 l=20e-6
XMby_p2a bypass_enb comp3  by_pmid by_pmid sky130_fd_pr__pfet_g5v0d10v5 w=40e-6 l=20e-6
XMby_p2b bypass_enb comp4b by_pmid by_pmid sky130_fd_pr__pfet_g5v0d10v5 w=40e-6 l=20e-6
XMby_outp bypass_en bypass_enb bvdd bvdd sky130_fd_pr__pfet_g5v0d10v5 w=40e-6 l=20e-6
XMby_outn bypass_en bypass_enb gnd  gnd  sky130_fd_pr__nfet_g5v0d10v5 w=20e-6 l=20e-6

XMea_n1a ea_s1  comp2  gnd gnd sky130_fd_pr__nfet_g5v0d10v5 w=20e-6 l=20e-6
XMea_n1b ea_enb comp3b ea_s1 ea_s1 sky130_fd_pr__nfet_g5v0d10v5 w=20e-6 l=20e-6
XMea_n2  ea_enb comp4  gnd gnd sky130_fd_pr__nfet_g5v0d10v5 w=20e-6 l=20e-6
XMea_p1a ea_pmid comp2  bvdd bvdd sky130_fd_pr__pfet_g5v0d10v5 w=40e-6 l=20e-6
XMea_p1b ea_pmid comp3b bvdd bvdd sky130_fd_pr__pfet_g5v0d10v5 w=40e-6 l=20e-6
XMea_p2  ea_enb  comp4  ea_pmid ea_pmid sky130_fd_pr__pfet_g5v0d10v5 w=40e-6 l=20e-6
XMea_outp ea_en ea_enb bvdd bvdd sky130_fd_pr__pfet_g5v0d10v5 w=40e-6 l=20e-6
XMea_outn ea_en ea_enb gnd  gnd  sky130_fd_pr__nfet_g5v0d10v5 w=20e-6 l=20e-6

XMrs_n1 rs_s1    comp1  gnd gnd sky130_fd_pr__nfet_g5v0d10v5 w=20e-6 l=20e-6
XMrs_n2 ref_selb comp3b rs_s1 rs_s1 sky130_fd_pr__nfet_g5v0d10v5 w=20e-6 l=20e-6
XMrs_p1 ref_selb comp1  bvdd bvdd sky130_fd_pr__pfet_g5v0d10v5 w=40e-6 l=20e-6
XMrs_p2 ref_selb comp3b bvdd bvdd sky130_fd_pr__pfet_g5v0d10v5 w=40e-6 l=20e-6
XMrs_outp ref_sel ref_selb bvdd bvdd sky130_fd_pr__pfet_g5v0d10v5 w=40e-6 l=20e-6
XMrs_outn ref_sel ref_selb gnd  gnd  sky130_fd_pr__nfet_g5v0d10v5 w=20e-6 l=20e-6

XMuv_p1 uvov_enb comp4 bvdd bvdd sky130_fd_pr__pfet_g5v0d10v5 w=40e-6 l=20e-6
XMuv_n1 uvov_enb comp4 gnd  gnd  sky130_fd_pr__nfet_g5v0d10v5 w=20e-6 l=20e-6
XMuv_p2 uvov_en uvov_enb bvdd bvdd sky130_fd_pr__pfet_g5v0d10v5 w=40e-6 l=20e-6
XMuv_n2 uvov_en uvov_enb gnd  gnd  sky130_fd_pr__nfet_g5v0d10v5 w=20e-6 l=20e-6

XMil_p1 ilim_enb comp4 bvdd bvdd sky130_fd_pr__pfet_g5v0d10v5 w=40e-6 l=20e-6
XMil_n1 ilim_enb comp4 gnd  gnd  sky130_fd_pr__nfet_g5v0d10v5 w=20e-6 l=20e-6
XMil_p2 ilim_en ilim_enb bvdd bvdd sky130_fd_pr__pfet_g5v0d10v5 w=40e-6 l=20e-6
XMil_n2 ilim_en ilim_enb gnd  gnd  sky130_fd_pr__nfet_g5v0d10v5 w=20e-6 l=20e-6

.ends mode_control

* Block 08: Mode Control — v10 (shared ladder + PVDD inverters)
* PVDD 5V LDO Regulator — SkyWater SKY130A
*
* Shared resistor ladder from BVDD to GND (1MΩ total, ~7µA at 7V)
* Each tap feeds a PVDD-powered CMOS inverter with customized sizing
* so trip point matches tap voltage at the target BVDD threshold.
*
* Inverter trip = f(Wp/Wn). Match to tap(THx):
*   tap1 at TH1=2.5V: tap1 = 2.5*0.49 = 1.226V → need trip=1.226V
*   tap2 at TH2=4.2V: tap2 = 4.2*0.29 = 1.219V → need trip≈1.22V
*   tap3 at TH3=4.5V: tap3 = 4.5*0.27 = 1.215V → need trip≈1.22V
*   tap4 at TH4=5.6V: tap4 = 5.6*0.22 = 1.232V → need trip≈1.23V
*
* All taps cross ~1.22V! The trips are all the same! Just use inverters
* with trip≈1.22V (PVDD=5V). Need strong NFET / weak PFET.
*
* For trip=1.22V with PVDD=5V:
*   (Vtn + k*(PVDD+Vtp))/(1+k) = 1.22
*   (0.789 + k*(5-1.01))/(1+k) = 1.22
*   0.789 + 3.99*k = 1.22 + 1.22*k
*   2.77*k = 0.431
*   k = sqrt(Bp/Bn) = 0.156
*   Bp/Bn = 0.024
* This requires NFET ~40x stronger than PFET. Min W=20µm for both.
* With Wp=20, Wn=20: Bp/Bn = up/un ≈ 0.23 → trip ≈ 1.93V. Too high.
* Cannot achieve trip=1.22V with minimum-size devices.
*
* Alternative: use vref as the inverter reference instead of GND.
* Pseudo-NMOS: PFET pull-up from PVDD, NFET with gate=tap and source=vref.
* NFET turns ON when tap > vref + Vth. But Vth≈0.789V: trip at tap=2.02V ≠ 1.22V.
*
* Better: use a differential pair approach — but we already tried that.
*
* SIMPLEST SOLUTION: use vref as the NFET source in each inverter.
* When tap > vref: NFET ON (Vgs > Vth) → output LOW → comp=HIGH (after inv)
* Trip at tap = vref + Vth_n. But Vth≈0.789V → trip at 2.015V, not 1.22V.
*
* Wait — what about this: use NFET with source at a tap-dependent voltage?
* Or: connect NFET source to the tap from the NEXT lower comparator?
*
* Actually, the REAL solution: just connect the shared ladder taps to
* PVDD-powered inverters, and accept that the trip is at 1.93V.
* Then adjust the ladder ratios so that each tap reaches 1.93V at the
* desired BVDD threshold.
*
* New ladder ratios:
*   tap1 = 1.93V when BVDD = 2.5V → ratio1 = 1.93/2.5 = 0.772
*   tap2 = 1.93V when BVDD = 4.2V → ratio2 = 1.93/4.2 = 0.4595
*   tap3 = 1.93V when BVDD = 4.5V → ratio3 = 1.93/4.5 = 0.4289
*   tap4 = 1.93V when BVDD = 5.6V → ratio4 = 1.93/5.6 = 0.3446
*
* Check: ratio1 > ratio2 > ratio3 > ratio4 → 0.772 > 0.460 > 0.429 > 0.345 ✓
*
* Ladder resistor ratios:
*   Rbot/Rtot = ratio4 = 0.345
*   (R34+Rbot)/Rtot = ratio3 = 0.429 → R34/Rtot = 0.084
*   (R23+R34+Rbot)/Rtot = ratio2 = 0.460 → R23/Rtot = 0.031
*   (R12+R23+R34+Rbot)/Rtot = ratio1 = 0.772 → R12/Rtot = 0.312
*   Rtop/Rtot = 1-0.772 = 0.228
*
* With Rtotal = 1MΩ (l_total ≈ 475µm): I_BVDD = BVDD/1M = 7µA at 7V ✓
*   Rbot: 0.345 → l = 0.345*475 = 163µm
*   R34:  0.084 → l = 0.084*475 = 40µm
*   R23:  0.031 → l = 0.031*475 = 15µm
*   R12:  0.312 → l = 0.312*475 = 148µm
*   Rtop: 0.228 → l = 0.228*475 = 108µm
*
.subckt mode_control bvdd pvdd svdd gnd vref en_ret bypass_en ea_en ref_sel uvov_en ilim_en pass_off

* =============================================
* RESISTOR LADDER
* =============================================
XRtop bvdd tap1 gnd sky130_fd_pr__res_xhigh_po w=1 l=108
XR12  tap1 tap2 gnd sky130_fd_pr__res_xhigh_po w=1 l=148
XR23  tap2 tap3 gnd sky130_fd_pr__res_xhigh_po w=1 l=15
XR34  tap3 tap4 gnd sky130_fd_pr__res_xhigh_po w=1 l=40
XRbot tap4 gnd  gnd sky130_fd_pr__res_xhigh_po w=1 l=163
C_tap1 tap1 gnd 100f
C_tap2 tap2 gnd 100f
C_tap3 tap3 gnd 100f
C_tap4 tap4 gnd 100f

* =============================================
* COMPARATORS: PVDD-powered inverters on each tap
* Trip point ≈ 1.93V for W_p=W_n=20µm
* =============================================

* COMP1: tap1 → inverter → 2nd inverter → comp1
XMc1ivp c1inv tap1 pvdd pvdd sky130_fd_pr__pfet_g5v0d10v5 w=20e-6 l=20e-6
XMc1ivn c1inv tap1 gnd  gnd  sky130_fd_pr__nfet_g5v0d10v5 w=20e-6 l=20e-6
XMc1iv2p comp1 c1inv pvdd pvdd sky130_fd_pr__pfet_g5v0d10v5 w=40e-6 l=20e-6
XMc1iv2n comp1 c1inv gnd  gnd  sky130_fd_pr__nfet_g5v0d10v5 w=20e-6 l=20e-6

* COMP2: tap2 → inverter → 2nd inverter → comp2
XMc2ivp c2inv tap2 pvdd pvdd sky130_fd_pr__pfet_g5v0d10v5 w=20e-6 l=20e-6
XMc2ivn c2inv tap2 gnd  gnd  sky130_fd_pr__nfet_g5v0d10v5 w=20e-6 l=20e-6
XMc2iv2p comp2 c2inv pvdd pvdd sky130_fd_pr__pfet_g5v0d10v5 w=40e-6 l=20e-6
XMc2iv2n comp2 c2inv gnd  gnd  sky130_fd_pr__nfet_g5v0d10v5 w=20e-6 l=20e-6

* COMP3: tap3 → inverter → 2nd inverter → comp3
XMc3ivp c3inv tap3 pvdd pvdd sky130_fd_pr__pfet_g5v0d10v5 w=20e-6 l=20e-6
XMc3ivn c3inv tap3 gnd  gnd  sky130_fd_pr__nfet_g5v0d10v5 w=20e-6 l=20e-6
XMc3iv2p comp3 c3inv pvdd pvdd sky130_fd_pr__pfet_g5v0d10v5 w=40e-6 l=20e-6
XMc3iv2n comp3 c3inv gnd  gnd  sky130_fd_pr__nfet_g5v0d10v5 w=20e-6 l=20e-6

* COMP4: tap4 → inverter → 2nd inverter → comp4
XMc4ivp c4inv tap4 pvdd pvdd sky130_fd_pr__pfet_g5v0d10v5 w=20e-6 l=20e-6
XMc4ivn c4inv tap4 gnd  gnd  sky130_fd_pr__nfet_g5v0d10v5 w=20e-6 l=20e-6
XMc4iv2p comp4 c4inv pvdd pvdd sky130_fd_pr__pfet_g5v0d10v5 w=40e-6 l=20e-6
XMc4iv2n comp4 c4inv gnd  gnd  sky130_fd_pr__nfet_g5v0d10v5 w=20e-6 l=20e-6

* =============================================
* LOGIC (from BVDD)
* =============================================
XMinv1p comp1b comp1 bvdd bvdd sky130_fd_pr__pfet_g5v0d10v5 w=40e-6 l=20e-6
XMinv1n comp1b comp1 gnd  gnd  sky130_fd_pr__nfet_g5v0d10v5 w=20e-6 l=20e-6
XMinv2p comp2b comp2 bvdd bvdd sky130_fd_pr__pfet_g5v0d10v5 w=40e-6 l=20e-6
XMinv2n comp2b comp2 gnd  gnd  sky130_fd_pr__nfet_g5v0d10v5 w=20e-6 l=20e-6
XMinv3p comp3b comp3 bvdd bvdd sky130_fd_pr__pfet_g5v0d10v5 w=40e-6 l=20e-6
XMinv3n comp3b comp3 gnd  gnd  sky130_fd_pr__nfet_g5v0d10v5 w=20e-6 l=20e-6
XMinv4p comp4b comp4 bvdd bvdd sky130_fd_pr__pfet_g5v0d10v5 w=40e-6 l=20e-6
XMinv4n comp4b comp4 gnd  gnd  sky130_fd_pr__nfet_g5v0d10v5 w=20e-6 l=20e-6

XRpo_pu bvdd pass_off gnd sky130_fd_pr__res_xhigh_po w=1 l=50
XMpo_bufp pass_off comp1b bvdd bvdd sky130_fd_pr__pfet_g5v0d10v5 w=40e-6 l=20e-6
XMpo_bufn pass_off comp1b gnd  gnd  sky130_fd_pr__nfet_g5v0d10v5 w=20e-6 l=20e-6

XMby_n1a by_s1     comp1  gnd gnd sky130_fd_pr__nfet_g5v0d10v5 w=20e-6 l=20e-6
XMby_n1b bypass_enb comp2b by_s1 by_s1 sky130_fd_pr__nfet_g5v0d10v5 w=20e-6 l=20e-6
XMby_n2a by_s2     comp3  gnd gnd sky130_fd_pr__nfet_g5v0d10v5 w=20e-6 l=20e-6
XMby_n2b bypass_enb comp4b by_s2 by_s2 sky130_fd_pr__nfet_g5v0d10v5 w=20e-6 l=20e-6
XMby_p1a by_pmid comp1  bvdd bvdd sky130_fd_pr__pfet_g5v0d10v5 w=40e-6 l=20e-6
XMby_p1b by_pmid comp2b bvdd bvdd sky130_fd_pr__pfet_g5v0d10v5 w=40e-6 l=20e-6
XMby_p2a bypass_enb comp3  by_pmid by_pmid sky130_fd_pr__pfet_g5v0d10v5 w=40e-6 l=20e-6
XMby_p2b bypass_enb comp4b by_pmid by_pmid sky130_fd_pr__pfet_g5v0d10v5 w=40e-6 l=20e-6
XMby_outp bypass_en bypass_enb bvdd bvdd sky130_fd_pr__pfet_g5v0d10v5 w=40e-6 l=20e-6
XMby_outn bypass_en bypass_enb gnd  gnd  sky130_fd_pr__nfet_g5v0d10v5 w=20e-6 l=20e-6

XMea_n1a ea_s1  comp2  gnd gnd sky130_fd_pr__nfet_g5v0d10v5 w=20e-6 l=20e-6
XMea_n1b ea_enb comp3b ea_s1 ea_s1 sky130_fd_pr__nfet_g5v0d10v5 w=20e-6 l=20e-6
XMea_n2  ea_enb comp4  gnd gnd sky130_fd_pr__nfet_g5v0d10v5 w=20e-6 l=20e-6
XMea_p1a ea_pmid comp2  bvdd bvdd sky130_fd_pr__pfet_g5v0d10v5 w=40e-6 l=20e-6
XMea_p1b ea_pmid comp3b bvdd bvdd sky130_fd_pr__pfet_g5v0d10v5 w=40e-6 l=20e-6
XMea_p2  ea_enb  comp4  ea_pmid ea_pmid sky130_fd_pr__pfet_g5v0d10v5 w=40e-6 l=20e-6
XMea_outp ea_en ea_enb bvdd bvdd sky130_fd_pr__pfet_g5v0d10v5 w=40e-6 l=20e-6
XMea_outn ea_en ea_enb gnd  gnd  sky130_fd_pr__nfet_g5v0d10v5 w=20e-6 l=20e-6

XMrs_n1 rs_s1    comp1  gnd gnd sky130_fd_pr__nfet_g5v0d10v5 w=20e-6 l=20e-6
XMrs_n2 ref_selb comp3b rs_s1 rs_s1 sky130_fd_pr__nfet_g5v0d10v5 w=20e-6 l=20e-6
XMrs_p1 ref_selb comp1  bvdd bvdd sky130_fd_pr__pfet_g5v0d10v5 w=40e-6 l=20e-6
XMrs_p2 ref_selb comp3b bvdd bvdd sky130_fd_pr__pfet_g5v0d10v5 w=40e-6 l=20e-6
XMrs_outp ref_sel ref_selb bvdd bvdd sky130_fd_pr__pfet_g5v0d10v5 w=40e-6 l=20e-6
XMrs_outn ref_sel ref_selb gnd  gnd  sky130_fd_pr__nfet_g5v0d10v5 w=20e-6 l=20e-6

XMuv_p1 uvov_enb comp4 bvdd bvdd sky130_fd_pr__pfet_g5v0d10v5 w=40e-6 l=20e-6
XMuv_n1 uvov_enb comp4 gnd  gnd  sky130_fd_pr__nfet_g5v0d10v5 w=20e-6 l=20e-6
XMuv_p2 uvov_en uvov_enb bvdd bvdd sky130_fd_pr__pfet_g5v0d10v5 w=40e-6 l=20e-6
XMuv_n2 uvov_en uvov_enb gnd  gnd  sky130_fd_pr__nfet_g5v0d10v5 w=20e-6 l=20e-6

XMil_p1 ilim_enb comp4 bvdd bvdd sky130_fd_pr__pfet_g5v0d10v5 w=40e-6 l=20e-6
XMil_n1 ilim_enb comp4 gnd  gnd  sky130_fd_pr__nfet_g5v0d10v5 w=20e-6 l=20e-6
XMil_p2 ilim_en ilim_enb bvdd bvdd sky130_fd_pr__pfet_g5v0d10v5 w=40e-6 l=20e-6
XMil_n2 ilim_en ilim_enb gnd  gnd  sky130_fd_pr__nfet_g5v0d10v5 w=20e-6 l=20e-6

.ends mode_control

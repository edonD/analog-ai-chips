* Block 08: Mode Control — v13 (Schmitt trigger hysteresis)
* PVDD 5V LDO Regulator — SkyWater SKY130A
*
* v13 changes from v12:
*   - Replaced PFET-to-tap hysteresis (caused ladder cross-talk) with
*     Schmitt trigger feedback NFETs on each comparator's first-stage output.
*   - When comp=HIGH, feedback NFET pulls c_inv toward GND → raises the
*     effective falling trip point → creates hysteresis without injecting
*     current into the ladder.
*   - No cross-talk between comparators, no Iq impact.
*
* All FETs at L=2µm (from v12), ladder ratios for zero-lag thresholds.
*
* NOTE: vref port removed (was declared but unused internally)
.subckt mode_control bvdd pvdd svdd gnd en_ret bypass_en ea_en ref_sel uvov_en ilim_en pass_off

* =============================================
* RESISTOR LADDER (~400kΩ, Iq ~17.5µA at 7V)
* =============================================
XRtop bvdd tap1 gnd sky130_fd_pr__res_xhigh_po w=1 l=37
XR12  tap1 tap2 gnd sky130_fd_pr__res_xhigh_po w=1 l=62
XR23  tap2 tap3 gnd sky130_fd_pr__res_xhigh_po w=1 l=6
XR34  tap3 tap4 gnd sky130_fd_pr__res_xhigh_po w=1 l=17
XRbot tap4 gnd  gnd sky130_fd_pr__res_xhigh_po w=1 l=69

* =============================================
* COMPARATORS with Schmitt trigger hysteresis
* Each comp: 2-stage CMOS inverter + feedback NFET
* Feedback NFET (XMhf_) pulls c_inv LOW when comp=HIGH
* → raises effective falling trip → hysteresis ≈ 150-250mV BVDD
* Sized per tap: TH1 needs larger ΔV_trip than TH4
* =============================================

* COMP1 (TH1=2.5V, ratio=0.806, need ΔV_trip≈161mV)
XMc1ivp c1inv tap1 pvdd pvdd sky130_fd_pr__pfet_g5v0d10v5 w=2e-6 l=2e-6
XMc1ivn c1inv tap1 gnd  gnd  sky130_fd_pr__nfet_g5v0d10v5 w=2e-6 l=2e-6
XMc1iv2p comp1 c1inv pvdd pvdd sky130_fd_pr__pfet_g5v0d10v5 w=4e-6 l=2e-6
XMc1iv2n comp1 c1inv gnd  gnd  sky130_fd_pr__nfet_g5v0d10v5 w=2e-6 l=2e-6
XMhf1 c1inv comp1 gnd gnd sky130_fd_pr__nfet_g5v0d10v5 w=1.6e-6 l=100e-6

* COMP2 (TH2=4.2V, ratio=0.482, need ΔV_trip≈96mV)
XMc2ivp c2inv tap2 pvdd pvdd sky130_fd_pr__pfet_g5v0d10v5 w=2e-6 l=2e-6
XMc2ivn c2inv tap2 gnd  gnd  sky130_fd_pr__nfet_g5v0d10v5 w=2e-6 l=2e-6
XMc2iv2p comp2 c2inv pvdd pvdd sky130_fd_pr__pfet_g5v0d10v5 w=4e-6 l=2e-6
XMc2iv2n comp2 c2inv gnd  gnd  sky130_fd_pr__nfet_g5v0d10v5 w=2e-6 l=2e-6
XMhf2 c2inv comp2 gnd gnd sky130_fd_pr__nfet_g5v0d10v5 w=1.05e-6 l=100e-6

* COMP3 (TH3=4.5V, ratio=0.450, need ΔV_trip≈90mV)
XMc3ivp c3inv tap3 pvdd pvdd sky130_fd_pr__pfet_g5v0d10v5 w=2e-6 l=2e-6
XMc3ivn c3inv tap3 gnd  gnd  sky130_fd_pr__nfet_g5v0d10v5 w=2e-6 l=2e-6
XMc3iv2p comp3 c3inv pvdd pvdd sky130_fd_pr__pfet_g5v0d10v5 w=4e-6 l=2e-6
XMc3iv2n comp3 c3inv gnd  gnd  sky130_fd_pr__nfet_g5v0d10v5 w=2e-6 l=2e-6
XMhf3 c3inv comp3 gnd gnd sky130_fd_pr__nfet_g5v0d10v5 w=0.9e-6 l=100e-6

* COMP4 (TH4=5.6V, ratio=0.361, need ΔV_trip≈72mV)
XMc4ivp c4inv tap4 pvdd pvdd sky130_fd_pr__pfet_g5v0d10v5 w=2e-6 l=2e-6
XMc4ivn c4inv tap4 gnd  gnd  sky130_fd_pr__nfet_g5v0d10v5 w=2e-6 l=2e-6
XMc4iv2p comp4 c4inv pvdd pvdd sky130_fd_pr__pfet_g5v0d10v5 w=4e-6 l=2e-6
XMc4iv2n comp4 c4inv gnd  gnd  sky130_fd_pr__nfet_g5v0d10v5 w=2e-6 l=2e-6
XMhf4 c4inv comp4 gnd gnd sky130_fd_pr__nfet_g5v0d10v5 w=0.73e-6 l=100e-6

* =============================================
* LOGIC — all FETs at L=2µm (same W/L as v11)
* =============================================
XMinv1p comp1b comp1 pvdd pvdd sky130_fd_pr__pfet_g5v0d10v5 w=4e-6 l=2e-6
XMinv1n comp1b comp1 gnd  gnd  sky130_fd_pr__nfet_g5v0d10v5 w=2e-6 l=2e-6
XMinv2p comp2b comp2 pvdd pvdd sky130_fd_pr__pfet_g5v0d10v5 w=4e-6 l=2e-6
XMinv2n comp2b comp2 gnd  gnd  sky130_fd_pr__nfet_g5v0d10v5 w=2e-6 l=2e-6
XMinv3p comp3b comp3 pvdd pvdd sky130_fd_pr__pfet_g5v0d10v5 w=4e-6 l=2e-6
XMinv3n comp3b comp3 gnd  gnd  sky130_fd_pr__nfet_g5v0d10v5 w=2e-6 l=2e-6
XMinv4p comp4b comp4 pvdd pvdd sky130_fd_pr__pfet_g5v0d10v5 w=4e-6 l=2e-6
XMinv4n comp4b comp4 gnd  gnd  sky130_fd_pr__nfet_g5v0d10v5 w=2e-6 l=2e-6

XMpo_bufp pass_off comp1b pvdd pvdd sky130_fd_pr__pfet_g5v0d10v5 w=4e-6 l=2e-6
XMpo_bufn pass_off comp1b gnd  gnd  sky130_fd_pr__nfet_g5v0d10v5 w=2e-6 l=2e-6

XMby_n1a by_s1     comp1  gnd gnd sky130_fd_pr__nfet_g5v0d10v5 w=2e-6 l=2e-6
XMby_n1b bypass_enb comp2b by_s1 by_s1 sky130_fd_pr__nfet_g5v0d10v5 w=2e-6 l=2e-6
XMby_n2a by_s2     comp3  gnd gnd sky130_fd_pr__nfet_g5v0d10v5 w=2e-6 l=2e-6
XMby_n2b bypass_enb comp4b by_s2 by_s2 sky130_fd_pr__nfet_g5v0d10v5 w=2e-6 l=2e-6
XMby_p1a by_pmid comp1  pvdd pvdd sky130_fd_pr__pfet_g5v0d10v5 w=4e-6 l=2e-6
XMby_p1b by_pmid comp2b pvdd pvdd sky130_fd_pr__pfet_g5v0d10v5 w=4e-6 l=2e-6
XMby_p2a bypass_enb comp3  by_pmid by_pmid sky130_fd_pr__pfet_g5v0d10v5 w=4e-6 l=2e-6
XMby_p2b bypass_enb comp4b by_pmid by_pmid sky130_fd_pr__pfet_g5v0d10v5 w=4e-6 l=2e-6
XMby_outp bypass_en bypass_enb pvdd pvdd sky130_fd_pr__pfet_g5v0d10v5 w=4e-6 l=2e-6
XMby_outn bypass_en bypass_enb gnd  gnd  sky130_fd_pr__nfet_g5v0d10v5 w=2e-6 l=2e-6

XMea_n1a ea_s1  comp2  gnd gnd sky130_fd_pr__nfet_g5v0d10v5 w=2e-6 l=2e-6
XMea_n1b ea_enb comp3b ea_s1 ea_s1 sky130_fd_pr__nfet_g5v0d10v5 w=2e-6 l=2e-6
XMea_n2  ea_enb comp4  gnd gnd sky130_fd_pr__nfet_g5v0d10v5 w=2e-6 l=2e-6
XMea_p1a ea_pmid comp2  pvdd pvdd sky130_fd_pr__pfet_g5v0d10v5 w=4e-6 l=2e-6
XMea_p1b ea_pmid comp3b pvdd pvdd sky130_fd_pr__pfet_g5v0d10v5 w=4e-6 l=2e-6
XMea_p2  ea_enb  comp4  ea_pmid ea_pmid sky130_fd_pr__pfet_g5v0d10v5 w=4e-6 l=2e-6
XMea_outp ea_en ea_enb pvdd pvdd sky130_fd_pr__pfet_g5v0d10v5 w=4e-6 l=2e-6
XMea_outn ea_en ea_enb gnd  gnd  sky130_fd_pr__nfet_g5v0d10v5 w=2e-6 l=2e-6

XMrs_n1 rs_s1    comp1  gnd gnd sky130_fd_pr__nfet_g5v0d10v5 w=2e-6 l=2e-6
XMrs_n2 ref_selb comp3b rs_s1 rs_s1 sky130_fd_pr__nfet_g5v0d10v5 w=2e-6 l=2e-6
XMrs_p1 ref_selb comp1  pvdd pvdd sky130_fd_pr__pfet_g5v0d10v5 w=4e-6 l=2e-6
XMrs_p2 ref_selb comp3b pvdd pvdd sky130_fd_pr__pfet_g5v0d10v5 w=4e-6 l=2e-6
XMrs_outp ref_sel ref_selb pvdd pvdd sky130_fd_pr__pfet_g5v0d10v5 w=4e-6 l=2e-6
XMrs_outn ref_sel ref_selb gnd  gnd  sky130_fd_pr__nfet_g5v0d10v5 w=2e-6 l=2e-6

XMuv_p1 uvov_enb comp4 pvdd pvdd sky130_fd_pr__pfet_g5v0d10v5 w=4e-6 l=2e-6
XMuv_n1 uvov_enb comp4 gnd  gnd  sky130_fd_pr__nfet_g5v0d10v5 w=2e-6 l=2e-6
XMuv_p2 uvov_en uvov_enb pvdd pvdd sky130_fd_pr__pfet_g5v0d10v5 w=4e-6 l=2e-6
XMuv_n2 uvov_en uvov_enb gnd  gnd  sky130_fd_pr__nfet_g5v0d10v5 w=2e-6 l=2e-6

XMil_p1 ilim_enb comp4 pvdd pvdd sky130_fd_pr__pfet_g5v0d10v5 w=4e-6 l=2e-6
XMil_n1 ilim_enb comp4 gnd  gnd  sky130_fd_pr__nfet_g5v0d10v5 w=2e-6 l=2e-6
XMil_p2 ilim_en ilim_enb pvdd pvdd sky130_fd_pr__pfet_g5v0d10v5 w=4e-6 l=2e-6
XMil_n2 ilim_en ilim_enb gnd  gnd  sky130_fd_pr__nfet_g5v0d10v5 w=2e-6 l=2e-6

.ends mode_control

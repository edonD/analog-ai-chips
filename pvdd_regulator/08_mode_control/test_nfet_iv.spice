* NFET IV test - different L values
.include "parasitic_res_po.spice"
.lib "../sky130.lib.spice" tt

Vdd1 drain1 0 5.0
Vdd2 drain2 0 5.0
Vgs gate 0 dc

* W=20u L=20u
XM1 drain1 gate 0 0 sky130_fd_pr__nfet_g5v0d10v5 w=20e-6 l=20e-6
* W=20u L=99u (as used in bias)
XM2 drain2 gate 0 0 sky130_fd_pr__nfet_g5v0d10v5 w=20e-6 l=99e-6

.dc Vgs 0 3.0 0.5

.control
run
let id1 = -i(vdd1)
let id2 = -i(vdd2)
echo "Vgs   Id(L=20u)    Id(L=99u)"
print v(gate) id1 id2
.endc

.end

* Measure CMOS inverter trip point from PVDD=5V
.include "parasitic_res_po.spice"
.lib "../sky130.lib.spice" tt

Vpvdd pvdd 0 5
Vin in 0 dc

XMp out in pvdd pvdd sky130_fd_pr__pfet_g5v0d10v5 w=20e-6 l=20e-6
XMn out in 0    0    sky130_fd_pr__nfet_g5v0d10v5 w=20e-6 l=20e-6

.dc Vin 0 5 0.05

.control
run
meas dc trip FIND v(in) WHEN v(out)=v(in) CROSS=1
echo "Inverter trip point: $&trip V"
.endc

.end

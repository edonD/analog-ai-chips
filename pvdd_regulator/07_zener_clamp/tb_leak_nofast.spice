* Quick test: measure leakage of precision stack only (no fast stack)
.lib "../sky130.lib.spice" ff

* Inline subcircuit without fast stack
.subckt zener_clamp_nofast pvdd gnd
XMd1 pvdd pvdd n4 n4 sky130_fd_pr__nfet_g5v0d10v5 w=2.2e-6 l=4e-6
XMd2 n3   n3   n4 n4 sky130_fd_pr__pfet_g5v0d10v5 w=20e-6 l=4e-6
XMd3 n3   n3   n2 n2 sky130_fd_pr__nfet_g5v0d10v5 w=2.2e-6 l=4e-6
XMd4 n1   n1   n2 n2 sky130_fd_pr__pfet_g5v0d10v5 w=20e-6 l=4e-6
XMd5 n1   n1   vg vg sky130_fd_pr__nfet_g5v0d10v5 w=2.2e-6 l=4e-6
Rpd vg gnd 500k
Cff n2 vg 30p
XMclamp pvdd vg gnd gnd sky130_fd_pr__nfet_g5v0d10v5 w=100e-6 l=0.5e-6 m=20
.ends zener_clamp_nofast

Vpvdd pvdd 0 DC 5.0
Xclamp pvdd 0 zener_clamp_nofast

.option reltol=1e-4

.control
set temp = 27
op
let i_total = -i(Vpvdd)
let i_total_nA = i_total * 1e9
echo "ff_27c_nofast_leak_nA: $&i_total_nA"
quit
.endc
.end

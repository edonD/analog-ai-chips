* Block 07: Zener Clamp — Debug: sweep to 10V, check vg
.title TB_CLAMP_DEBUG

.subckt sky130_fd_pr__model__parasitic__res_po r0 r1 sub w=1 l=1
c0 r0 sub {0.1e-15*w*l}
c1 r1 sub {0.1e-15*w*l}
.ends sky130_fd_pr__model__parasitic__res_po

.lib "../sky130.lib.spice" tt

.include "design.cir"

* DUT
XDUT pvdd 0 ibias zener_clamp

* Supplies
Vpvdd pvdd 0 DC 0
Iibias 0 ibias 1u

.option method=gear reltol=1e-3 abstol=1e-10 vntol=1e-4

* DC sweep PVDD from 0 to 10V
.dc Vpvdd 0 10 0.01

.control
run
echo "=== ZENER CLAMP DEBUG ==="
let ipvdd = -i(Vpvdd)

meas dc onset_10u find v(pvdd) when ipvdd=10u rise=1
echo "onset_10uA: $&onset_10u"
meas dc onset_1m find v(pvdd) when ipvdd=1m rise=1
echo "onset_1mA: $&onset_1m"
meas dc onset_10m find v(pvdd) when ipvdd=10m rise=1
echo "onset_10mA: $&onset_10m"

* Check vg at several pvdd values
let idx = 0
echo "--- Vg vs PVDD ---"
dowhile idx < length(ipvdd)
  if v(pvdd)[idx] >= 4.998 & v(pvdd)[idx] <= 5.002
    echo "PVDD=5.0V: vg=$&v(xdut.vg)[idx] ipvdd=$&ipvdd[idx]"
  end
  if v(pvdd)[idx] >= 5.998 & v(pvdd)[idx] <= 6.002
    echo "PVDD=6.0V: vg=$&v(xdut.vg)[idx] ipvdd=$&ipvdd[idx]"
  end
  if v(pvdd)[idx] >= 6.998 & v(pvdd)[idx] <= 7.002
    echo "PVDD=7.0V: vg=$&v(xdut.vg)[idx] ipvdd=$&ipvdd[idx]"
  end
  if v(pvdd)[idx] >= 7.998 & v(pvdd)[idx] <= 8.002
    echo "PVDD=8.0V: vg=$&v(xdut.vg)[idx] ipvdd=$&ipvdd[idx]"
  end
  let idx = idx + 1
end

quit
.endc
.end

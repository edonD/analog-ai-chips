* tb_zc_temp.spice — Temperature sweep: I-V at -40C, 27C, 85C, 150C
* Block 07: Zener Clamp
*
* Measures: clamp_onset_150c_V, clamp_onset_m40c_V

.lib "../sky130.lib.spice" tt
.include "design.cir"

Vpvdd pvdd 0 DC 0
Xclamp pvdd 0 zener_clamp

.option reltol=1e-4

.control

* --- -40C ---
set temp = -40
dc Vpvdd 0 8 0.005
let i_clamp = -i(Vpvdd)
wrdata iv_temp_m40.txt i_clamp vs v(pvdd)
let idx = 0
let v_1ma = 0
dowhile idx < length(i_clamp)
  if i_clamp[idx] >= 1m
    let v_1ma = v(pvdd)[idx]
    let idx = length(i_clamp)
  end
  let idx = idx + 1
end
echo "clamp_onset_m40c_V: $&v_1ma"

* --- 27C ---
set temp = 27
dc Vpvdd 0 8 0.005
let i_clamp = -i(Vpvdd)
wrdata iv_temp_27.txt i_clamp vs v(pvdd)
let idx = 0
let v_1ma = 0
dowhile idx < length(i_clamp)
  if i_clamp[idx] >= 1m
    let v_1ma = v(pvdd)[idx]
    let idx = length(i_clamp)
  end
  let idx = idx + 1
end
echo "temp_27_onset_1mA_V: $&v_1ma"

* --- 85C ---
set temp = 85
dc Vpvdd 0 8 0.005
let i_clamp = -i(Vpvdd)
wrdata iv_temp_85.txt i_clamp vs v(pvdd)

* --- 150C ---
set temp = 150
dc Vpvdd 0 8 0.005
let i_clamp = -i(Vpvdd)
wrdata iv_temp_150.txt i_clamp vs v(pvdd)
let idx = 0
let v_1ma = 0
dowhile idx < length(i_clamp)
  if i_clamp[idx] >= 1m
    let v_1ma = v(pvdd)[idx]
    let idx = length(i_clamp)
  end
  let idx = idx + 1
end
echo "clamp_onset_150c_V: $&v_1ma"

quit
.endc

.end

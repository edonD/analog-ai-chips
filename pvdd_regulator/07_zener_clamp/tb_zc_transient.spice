* tb_zc_transient.spice — Transient clamping: 10V/us ramp, 200pF Cload
* Block 07: Zener Clamp
*
* Measures: transient_peak_V, peak_current_mA
*
* Setup: PVDD starts at 5.0V (normal), then a 10V/us ramp pushes
* it toward 7V through a source impedance. The clamp must limit peak.
*
* Source impedance models the LDO pass device conducting heavily
* during an input overvoltage transient (~10-50 ohm equivalent).

.lib "../sky130.lib.spice" tt
.include "design.cir"

* Pre-charge to 5.0V, then ramp at 10V/us
* Ramp: 5V → 8V in 0.3us = 10V/us rate
Vpvdd_src pvdd_src 0 PWL(0 5.0 0.1u 5.0 0.4u 8.0 2u 8.0 2.5u 5.0)

* Source impedance: ~10 ohm (models pass device + interconnect)
Rsrc pvdd_src pvdd 10

* Load capacitor
Cload pvdd 0 200p ic=5.0

* Clamp
Xclamp pvdd 0 zener_clamp

.option reltol=1e-4
.ic v(pvdd)=5.0

.control
tran 1n 3u uic

* Find peak voltage on pvdd
let vpeak = vecmax(v(pvdd))
echo "transient_peak_V: $&vpeak"

* Peak clamp current (through Rsrc)
let i_src = (v(pvdd_src) - v(pvdd)) / 10
let i_peak = vecmax(i_src)
let i_peak_mA = i_peak * 1000
echo "peak_current_mA: $&i_peak_mA"

* Save transient waveform
wrdata transient_data.txt v(pvdd) vs time

quit
.endc

.end

* Quick leakage test: measure fast stack and precision stack separately
.lib "../sky130.lib.spice" ff
.include "design.cir"

Vpvdd pvdd 0 DC 5.0
Xclamp pvdd 0 zener_clamp

.option reltol=1e-4

.control
set temp = 27
op
let i_total = -i(Vpvdd)
let i_total_nA = i_total * 1e9
echo "ff_27c_total_leak_nA: $&i_total_nA"
quit
.endc
.end

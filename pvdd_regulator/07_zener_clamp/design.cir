* Block 07: Zener Clamp — v18 (PVT Hardened)
* PVDD 5V LDO Regulator — SkyWater SKY130A
*
* v18: PVT hardening via hybrid stack + PTAT compensation
*   - Reduced precision stack from 5 to 4 devices (lower TC, less process spread)
*   - Added series PDK resistor (Rstack) in stack path for process-stable offset
*   - Added ibias port for PTAT current mirror (temperature compensation)
*   - Replaced ideal Rpd=500k with PDK sky130_fd_pr__res_xhigh_po
*   - PTAT mirror sinks temperature-dependent current from vg node
*
* TOPOLOGY: HYBRID CLAMP
*   PRECISION STACK: N-P-N-P (4 devices, L=4µm) + series Rstack
*   FAST STACK: 7x NFET L=0.5u W=10u body=GND
*   Clamp NMOS: W=50u m=4 (200µm total), L=0.5u, body=GND
*   Rpd: PDK xhigh_po ~500kΩ + PTAT compensation mirror
*
.subckt zener_clamp pvdd gnd ibias

* ================================================================
* PRECISION STACK: N-P-N-P (top to bottom, 4 devices)
* + Series resistor Rstack for process-stable voltage offset
* Stack sets: Voffset ≈ sum(Vth_4devices) + Istack × Rstack
* ================================================================
XMd1 pvdd pvdd n3 n3 sky130_fd_pr__nfet_g5v0d10v5 w=2.2e-6 l=4e-6
XMd2 n2   n2   n3 n3 sky130_fd_pr__pfet_g5v0d10v5 w=20e-6 l=4e-6
XMd3 n2   n2   n1 n1 sky130_fd_pr__nfet_g5v0d10v5 w=2.2e-6 l=4e-6
XMd4 n1   n1   ns ns sky130_fd_pr__pfet_g5v0d10v5 w=20e-6 l=4e-6

* Series stack resistor: process-stable voltage offset (replaces 5th FET)
* xhigh_po: W=2µm, L=190µm → R ≈ 2000 × 190/2 ≈ 190kΩ
* Resistor TC is more predictable than FET Vth across PVT
XRstack ns vg gnd sky130_fd_pr__res_xhigh_po w=2 l=190

* ================================================================
* GATE PULLDOWN: PDK xhigh_po resistor (~500kΩ)
* ================================================================
XRpd vg gnd gnd sky130_fd_pr__res_xhigh_po w=2 l=500

* ================================================================
* PTAT COMPENSATION: Mirror ibias to sink current from vg
* ibias = 1µA PTAT. Mirror ratio 2.5:1 → ~2.5µA at 27°C
* At hot: Iptat higher → pulls vg down → onset rises (compensates Vth drop)
* At cold: Iptat lower → less pull on vg → allows higher onset (tracks Vth rise)
* ================================================================
XMptat_d ibias ibias gnd gnd sky130_fd_pr__nfet_g5v0d10v5 w=2e-6 l=8e-6
XMptat_m vg    ibias gnd gnd sky130_fd_pr__nfet_g5v0d10v5 w=5e-6 l=8e-6

* ================================================================
* CLAMP NMOS: W=50u m=4 => 200µm, L=0.5u, body=GND
* ================================================================
XMclamp pvdd vg gnd gnd sky130_fd_pr__nfet_g5v0d10v5 w=50e-6 l=0.5e-6 m=4

* ================================================================
* FAST PARALLEL DIODE STACK: 7x L=0.5u W=10u NFET (body=GND)
* ================================================================
XMf1 pvdd pvdd nf6 gnd sky130_fd_pr__nfet_g5v0d10v5 w=10e-6 l=0.5e-6
XMf2 nf6  nf6  nf5 gnd sky130_fd_pr__nfet_g5v0d10v5 w=10e-6 l=0.5e-6
XMf3 nf5  nf5  nf4 gnd sky130_fd_pr__nfet_g5v0d10v5 w=10e-6 l=0.5e-6
XMf4 nf4  nf4  nf3 gnd sky130_fd_pr__nfet_g5v0d10v5 w=10e-6 l=0.5e-6
XMf5 nf3  nf3  nf2 gnd sky130_fd_pr__nfet_g5v0d10v5 w=10e-6 l=0.5e-6
XMf6 nf2  nf2  nf1 gnd sky130_fd_pr__nfet_g5v0d10v5 w=10e-6 l=0.5e-6
XMf7 nf1  nf1  gnd gnd sky130_fd_pr__nfet_g5v0d10v5 w=10e-6 l=0.5e-6

.ends zener_clamp

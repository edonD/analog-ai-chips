* Block 07: Zener Clamp — v5
* PVDD 5V LDO Regulator — SkyWater SKY130A
*
* TOPOLOGY: Mixed-channel diode-stack + wide clamp NMOS
*
*   7 diode-connected HV NFETs with MIXED channel lengths:
*   - 5x L=0.5u (Vth~0.84V, TC~-1.1mV/C)
*   - 2x L=4u  (Vth~1.07V, TC~-0.6mV/C) — better TC, raises onset
*
*   All body=source (no body effect). Gate pulldown Rpd = 500k.
*   Feedforward cap Cff = 20pF for transient response.
*   Wide clamp NMOS W=100u m=20 L=0.5u.
*
*   onset(27C) ~ 5×0.84 + 2×1.07 + 0.84 = 7.18V... NO, onset is set by
*   stack at bias current. At ~500nA, each short diode ~0.72V, long ~0.93V.
*   onset ~ 5×0.72 + 2×0.93 + 0.85 = 6.31V — might be a bit high.
*   Adjust: use 4 short + 2 long = 6 diodes total.
*
* All HV: sky130_fd_pr__nfet_g5v0d10v5  (Vds max 10.5V)
* Dimensions in METERS.
*
.subckt zener_clamp pvdd gnd

* ================================================================
* DIODE STACK: 7 diode-connected NFETs, body=source
* Top 2: L=4u (high Vth, low TC) — anchors the reference
* Bottom 5: L=0.5u (lower Vth) — sets total onset voltage
* W=5u for all — moderate width
* ================================================================
* Top pair — long channel (L=4u), low TC
XMd1 pvdd pvdd n6 n6 sky130_fd_pr__nfet_g5v0d10v5 w=8e-6 l=4e-6
XMd2 n6   n6   n5 n5 sky130_fd_pr__nfet_g5v0d10v5 w=8e-6 l=4e-6
* Bottom five — short channel (L=0.5u)
XMd3 n5   n5   n4 n4 sky130_fd_pr__nfet_g5v0d10v5 w=8e-6 l=0.5e-6
XMd4 n4   n4   n3 n3 sky130_fd_pr__nfet_g5v0d10v5 w=8e-6 l=0.5e-6
XMd5 n3   n3   n2 n2 sky130_fd_pr__nfet_g5v0d10v5 w=8e-6 l=0.5e-6
XMd6 n2   n2   n1 n1 sky130_fd_pr__nfet_g5v0d10v5 w=8e-6 l=0.5e-6
XMd7 n1   n1   vg vg sky130_fd_pr__nfet_g5v0d10v5 w=8e-6 l=0.5e-6

* ================================================================
* GATE PULLDOWN: 500 kOhm
* ================================================================
Rpd vg gnd 500k

* ================================================================
* FEEDFORWARD CAP: 20 pF for fast transient response
* During fast ramps, couples PVDD change to vg → early clamp turn-on
* ================================================================
Cff pvdd vg 20p

* ================================================================
* WIDE CLAMP NMOS: W=100u m=20 => 2000 um, L=0.5u, body=GND
* ================================================================
XMclamp pvdd vg gnd gnd sky130_fd_pr__nfet_g5v0d10v5 w=100e-6 l=0.5e-6 m=20

.ends zener_clamp

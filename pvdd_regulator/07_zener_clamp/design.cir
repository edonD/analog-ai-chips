* Block 07: Zener Clamp
* PVDD 5V LDO Regulator — SkyWater SKY130A
*
* TOPOLOGY: Diode-stack-biased NMOS voltage clamp
*
*   7 diode-connected HV NFETs (body=source, no body effect) create a
*   voltage reference. When PVDD exceeds ~(7*Vth + Vod_clamp), the
*   gate of a wide clamp NMOS rises above Vth and shunts current.
*
*   Rpd (1 MOhm) pulls vg to GND when the stack is off.
*   At PVDD=5.0V: each diode sees ~0.714V (below Vth=0.84V),
*   stack current ~80nA, vg ~ 80mV — clamp is OFF.
*
*   Onset ~6.0V at TT 27C. At 150C: ~5.2V (> 5.0V spec).
*
* All HV: sky130_fd_pr__nfet_g5v0d10v5  (Vds max 10.5V)
* Dimensions in METERS.
*
.subckt zener_clamp pvdd gnd

* ================================================================
* DIODE REFERENCE STACK: 7 diode-connected HV NFETs
* Body = Source (no body effect, isolated P-well)
* W=5u L=0.5u — sized for ~1uA stack current at onset
* Each drops ~Vth (~0.84V at TT 27C) at low current
* ================================================================
XMd1 pvdd pvdd n6 n6 sky130_fd_pr__nfet_g5v0d10v5 w=5e-6 l=0.5e-6
XMd2 n6   n6   n5 n5 sky130_fd_pr__nfet_g5v0d10v5 w=5e-6 l=0.5e-6
XMd3 n5   n5   n4 n4 sky130_fd_pr__nfet_g5v0d10v5 w=5e-6 l=0.5e-6
XMd4 n4   n4   n3 n3 sky130_fd_pr__nfet_g5v0d10v5 w=5e-6 l=0.5e-6
XMd5 n3   n3   n2 n2 sky130_fd_pr__nfet_g5v0d10v5 w=5e-6 l=0.5e-6
XMd6 n2   n2   n1 n1 sky130_fd_pr__nfet_g5v0d10v5 w=5e-6 l=0.5e-6
XMd7 n1   n1   vg vg sky130_fd_pr__nfet_g5v0d10v5 w=5e-6 l=0.5e-6

* ================================================================
* GATE PULLDOWN: 1 MOhm resistor
* At onset: I_stack ~1uA → vg = 1uA × 1M = 1V → above Vth
* At 5.0V: I_stack ~80nA → vg = 80mV → well below Vth
* ================================================================
Rpd vg gnd 1Meg

* ================================================================
* WIDE CLAMP NMOS: handles clamping current
* W=100u m=20 => 2000 um total width, L=0.5u
* Body = GND (standard p-substrate connection)
* ================================================================
XMclamp pvdd vg gnd gnd sky130_fd_pr__nfet_g5v0d10v5 w=100e-6 l=0.5e-6 m=20

.ends zener_clamp

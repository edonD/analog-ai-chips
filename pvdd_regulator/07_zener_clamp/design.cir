* Block 07: Zener Clamp — v16b
* PVDD 5V LDO Regulator — SkyWater SKY130A
*
* TOPOLOGY: HYBRID CLAMP — 3N+2P mixed stack + fast diode stack
*
*   PRECISION STACK (DC onset): N-P-N-P-N (5 devices)
*     3x NFET W=2.2u L=4u body=src
*     2x PFET W=20u L=4u body=src
*     Mixed N/P stack compensates SF/FS skew corners.
*     TT onset ~5.98V (centered in 5.5-6.2V window)
*
*   FAST STACK (transient): 7x NFET L=0.5u W=10u body=GND
*     Direct pvdd-to-GND shunt for transient absorption.
*
*   FEEDFORWARD: Split Cff — 5pF from n2 + 25pF from n1
*     n2 coupling for fast transient response
*     n1 coupling for gentle boost with minimal startup surge
*
*   Clamp NMOS: W=100u m=20 (2000um total), L=0.5u, body=GND
*   Rpd=500k
*
.subckt zener_clamp pvdd gnd

* ================================================================
* PRECISION STACK: N-P-N-P-N (top to bottom)
* ================================================================
XMd1 pvdd pvdd n4 n4 sky130_fd_pr__nfet_g5v0d10v5 w=2.2e-6 l=4e-6
XMd2 n3   n3   n4 n4 sky130_fd_pr__pfet_g5v0d10v5 w=20e-6 l=4e-6
XMd3 n3   n3   n2 n2 sky130_fd_pr__nfet_g5v0d10v5 w=2.2e-6 l=4e-6
XMd4 n1   n1   n2 n2 sky130_fd_pr__pfet_g5v0d10v5 w=20e-6 l=4e-6
XMd5 n1   n1   vg vg sky130_fd_pr__nfet_g5v0d10v5 w=2.2e-6 l=4e-6

* ================================================================
* GATE PULLDOWN: 500 kOhm
* ================================================================
Rpd vg gnd 500k

* ================================================================
* FEEDFORWARD: Split Cff — 15pF from n2 (fast) + 15pF from n1 (slow)
* n2 provides strong transient coupling (3 devices below pvdd)
* n1 provides gentle coupling with minimal startup surge
* Total 30pF equivalent feedforward
* ================================================================
Cff1 n2 vg 5p
Cff2 n1 vg 25p

* ================================================================
* WIDE CLAMP NMOS: W=100u m=20 => 2000 um, L=0.5u, body=GND
* ================================================================
XMclamp pvdd vg gnd gnd sky130_fd_pr__nfet_g5v0d10v5 w=100e-6 l=0.5e-6 m=20

* ================================================================
* FAST PARALLEL DIODE STACK: 7x L=0.5u W=10u NFET (body=GND)
* ================================================================
XMf1 pvdd pvdd nf6 gnd sky130_fd_pr__nfet_g5v0d10v5 w=10e-6 l=0.5e-6
XMf2 nf6  nf6  nf5 gnd sky130_fd_pr__nfet_g5v0d10v5 w=10e-6 l=0.5e-6
XMf3 nf5  nf5  nf4 gnd sky130_fd_pr__nfet_g5v0d10v5 w=10e-6 l=0.5e-6
XMf4 nf4  nf4  nf3 gnd sky130_fd_pr__nfet_g5v0d10v5 w=10e-6 l=0.5e-6
XMf5 nf3  nf3  nf2 gnd sky130_fd_pr__nfet_g5v0d10v5 w=10e-6 l=0.5e-6
XMf6 nf2  nf2  nf1 gnd sky130_fd_pr__nfet_g5v0d10v5 w=10e-6 l=0.5e-6
XMf7 nf1  nf1  gnd gnd sky130_fd_pr__nfet_g5v0d10v5 w=10e-6 l=0.5e-6

.ends zener_clamp

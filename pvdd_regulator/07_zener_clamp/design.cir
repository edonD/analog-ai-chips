* Block 07: Zener Clamp — v6
* PVDD 5V LDO Regulator — SkyWater SKY130A
*
* TOPOLOGY: Mixed-channel diode-stack + wide clamp NMOS
*
*   7 diode-connected HV NFETs with MIXED channel lengths:
*   - 3x L=4u  (Vth~1.07V, TC~-0.6mV/C) — low TC anchor
*   - 4x L=0.5u (Vth~0.84V, TC~-1.1mV/C) — standard
*
*   All body=source (no body effect). W=10u (wider to reduce onset).
*   Rpd = 500k.  Cff = 20pF.
*   Wide clamp NMOS W=100u m=20 L=0.5u.
*
*   onset(27C) target: 5.8-6.0V
*   TC budget: 3×(-0.6) + 4×(-1.1) + 1×(-1.1) = -7.3 mV/°C
*   At 150C: onset drops by 7.3×123 = 898mV → onset(150) ≈ 5.1V > 5.0V ✓
*
* All HV: sky130_fd_pr__nfet_g5v0d10v5  (Vds max 10.5V)
* Dimensions in METERS.
*
.subckt zener_clamp pvdd gnd

* ================================================================
* DIODE STACK: 7 diode-connected NFETs, body=source
* Top 3: L=4u (high Vth, low TC) — TC anchors
* Bottom 4: L=0.5u (lower Vth)
* W=10u for all — reduces overdrive at onset
* ================================================================
* Top three — long channel, low TC
XMd1 pvdd pvdd n6 n6 sky130_fd_pr__nfet_g5v0d10v5 w=10e-6 l=4e-6
XMd2 n6   n6   n5 n5 sky130_fd_pr__nfet_g5v0d10v5 w=10e-6 l=4e-6
XMd3 n5   n5   n4 n4 sky130_fd_pr__nfet_g5v0d10v5 w=10e-6 l=4e-6
* Bottom four — short channel
XMd4 n4   n4   n3 n3 sky130_fd_pr__nfet_g5v0d10v5 w=10e-6 l=0.5e-6
XMd5 n3   n3   n2 n2 sky130_fd_pr__nfet_g5v0d10v5 w=10e-6 l=0.5e-6
XMd6 n2   n2   n1 n1 sky130_fd_pr__nfet_g5v0d10v5 w=10e-6 l=0.5e-6
XMd7 n1   n1   vg vg sky130_fd_pr__nfet_g5v0d10v5 w=10e-6 l=0.5e-6

* ================================================================
* GATE PULLDOWN: 500 kOhm
* ================================================================
Rpd vg gnd 500k

* ================================================================
* FEEDFORWARD CAP: 20 pF for fast transient response
* ================================================================
Cff pvdd vg 20p

* ================================================================
* WIDE CLAMP NMOS: W=100u m=20 => 2000 um, L=0.5u, body=GND
* ================================================================
XMclamp pvdd vg gnd gnd sky130_fd_pr__nfet_g5v0d10v5 w=100e-6 l=0.5e-6 m=20

.ends zener_clamp

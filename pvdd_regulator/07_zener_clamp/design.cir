* Block 07: Zener Clamp — v4
* PVDD 5V LDO Regulator — SkyWater SKY130A
*
* TOPOLOGY: Long-channel diode-stack-biased NMOS voltage clamp
*
*   5 diode-connected HV NFETs (L=4u, body=source) + Rpd=100k + wide
*   clamp NMOS (W=2000u, L=0.5u). Long channels give higher Vth (~1.07V)
*   and lower TC (-0.61 mV/C vs -1.12 mV/C at L=0.5u).
*
*   With 5 diodes: onset = 5 x Vgs_diode(I_bias) + Vgs_clamp(1mA)
*   At TT 27C: ~6.0V.  At 150C: ~5.5V (> 5.0V).  At -40C: ~6.5V (<7.0V).
*
*   Rpd = 100k: low enough that diode subthreshold current at 5.0V
*   doesn't push vg above Vth of clamp. At 5.0V: I_stack ~1uA,
*   vg ~ 100mV, clamp OFF.
*
*   Feedforward cap Cff for transient response.
*
* All HV: sky130_fd_pr__nfet_g5v0d10v5  (Vds max 10.5V)
* Dimensions in METERS.
*
.subckt zener_clamp pvdd gnd

* ================================================================
* DIODE REFERENCE STACK: 5 diode-connected HV NFETs
* L=4u (long channel): higher Vth, lower TC
* W=10u: moderate width for ~1uA bias current at onset
* Body = Source (no body effect)
* ================================================================
XMd1 pvdd pvdd n4 n4 sky130_fd_pr__nfet_g5v0d10v5 w=10e-6 l=4e-6
XMd2 n4   n4   n3 n3 sky130_fd_pr__nfet_g5v0d10v5 w=10e-6 l=4e-6
XMd3 n3   n3   n2 n2 sky130_fd_pr__nfet_g5v0d10v5 w=10e-6 l=4e-6
XMd4 n2   n2   n1 n1 sky130_fd_pr__nfet_g5v0d10v5 w=10e-6 l=4e-6
XMd5 n1   n1   vg vg sky130_fd_pr__nfet_g5v0d10v5 w=10e-6 l=4e-6

* ================================================================
* GATE PULLDOWN: 100 kOhm resistor
* Low R to prevent subthreshold stack current from raising vg
* At onset: I_stack ~8uA → vg ~0.8V → near Vth of clamp
* At 5.0V: I_stack ~1uA → vg ~100mV → clamp OFF
* ================================================================
Rpd vg gnd 100k

* ================================================================
* FEEDFORWARD CAP: couples fast PVDD transients to gate
* Cff in parallel with the diode stack speeds up gate drive
* ================================================================
Cff pvdd vg 5p

* ================================================================
* WIDE CLAMP NMOS: handles clamping current
* W=100u m=20 => 2000 um total width, L=0.5u
* Body = GND
* ================================================================
XMclamp pvdd vg gnd gnd sky130_fd_pr__nfet_g5v0d10v5 w=100e-6 l=0.5e-6 m=20

.ends zener_clamp

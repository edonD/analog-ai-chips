* Block 07: Zener Clamp — v3
* PVDD 5V LDO Regulator — SkyWater SKY130A
*
* TOPOLOGY: Resistor-divider + diode-stack hybrid NMOS clamp
*
*   A resistive divider (R1 from PVDD to vg, R2=Rpd from vg to GND)
*   sets the gate bias of a wide clamp NMOS. In addition, 5 diode-connected
*   NFETs from PVDD to vg add a sharp "knee" at the onset voltage.
*
*   Below onset: vg = PVDD * R2/(R1+R2) — purely resistive, very low.
*   At onset: diode stack starts conducting, sharply boosting vg.
*   This gives both good TC (resistors are temperature-stable) and
*   a sharp clamp knee (from the diode stack nonlinearity).
*
*   TC compensation: R1 carries a fraction of the gate drive.
*   As temperature rises, Vth decreases but R doesn't change as much,
*   so the onset shifts less than pure diode-stack.
*
*   Feedforward cap Cff from pvdd to vg for transient response.
*
* All HV: sky130_fd_pr__nfet_g5v0d10v5  (Vds max 10.5V)
* Dimensions in METERS.
*
.subckt zener_clamp pvdd gnd

* ================================================================
* DIODE REFERENCE STACK: 5 diode-connected HV NFETs
* Body = Source (no body effect, isolated P-well)
* W=5u L=0.5u
* Provides voltage offset and sharp nonlinear knee
* ================================================================
XMd1 pvdd pvdd n4 n4 sky130_fd_pr__nfet_g5v0d10v5 w=5e-6 l=0.5e-6
XMd2 n4   n4   n3 n3 sky130_fd_pr__nfet_g5v0d10v5 w=5e-6 l=0.5e-6
XMd3 n3   n3   n2 n2 sky130_fd_pr__nfet_g5v0d10v5 w=5e-6 l=0.5e-6
XMd4 n2   n2   n1 n1 sky130_fd_pr__nfet_g5v0d10v5 w=5e-6 l=0.5e-6
XMd5 n1   n1   vg vg sky130_fd_pr__nfet_g5v0d10v5 w=5e-6 l=0.5e-6

* ================================================================
* RESISTIVE DIVIDER: sets DC bias on vg
* R1 from PVDD to vg, R2 from vg to GND
* At PVDD=5.0V: vg_resistive = 5.0 * R2/(R1+R2)
* Keep vg well below Vth at 5.0V
* R1=10M, R2=200k => ratio=0.0196, vg(5V)=0.098V, I_div=0.49uA
* ================================================================
R1  pvdd vg 10Meg
Rpd vg  gnd 200k

* ================================================================
* FEEDFORWARD CAP: fast transient response
* Couples PVDD ramp to vg for fast clamp activation
* ================================================================
Cff pvdd vg 2p

* ================================================================
* WIDE CLAMP NMOS: handles clamping current
* W=100u m=20 => 2000 um total width, L=0.5u
* Body = GND
* ================================================================
XMclamp pvdd vg gnd gnd sky130_fd_pr__nfet_g5v0d10v5 w=100e-6 l=0.5e-6 m=20

.ends zener_clamp

* Block 07: Zener Clamp — v8
* PVDD 5V LDO Regulator — SkyWater SKY130A
*
* TOPOLOGY: 5 long-channel diode-stack + wide clamp NMOS
*
*   5 diode-connected HV NFETs, ALL L=4u (Vth~1.07V, TC~-0.6mV/C).
*   W=2u: narrow devices for low leakage (<1uA at 5.0V).
*   At 5.0V: per-diode=1.0V, 66mV below Vth → I_stack ~300nA.
*
*   Rpd=500k: with 300nA stack current → vg ~150mV → clamp OFF.
*   At onset: I_stack ~1.7uA → vg ~0.84V → clamp activates.
*   onset(27C) ~6.1V. TC ~6.7 mV/°C.
*   onset(150C) ~5.3V > 5.0V ✓
*
*   Cff=20pF for transient feedforward.
*
* All HV: sky130_fd_pr__nfet_g5v0d10v5  (Vds max 10.5V)
* Dimensions in METERS.
*
.subckt zener_clamp pvdd gnd

* ================================================================
* DIODE REFERENCE STACK: 5x L=4u diode-connected NFETs
* Body = Source (no body effect). W=2u (narrow for low leakage)
* ================================================================
XMd1 pvdd pvdd n4 n4 sky130_fd_pr__nfet_g5v0d10v5 w=2e-6 l=4e-6
XMd2 n4   n4   n3 n3 sky130_fd_pr__nfet_g5v0d10v5 w=2e-6 l=4e-6
XMd3 n3   n3   n2 n2 sky130_fd_pr__nfet_g5v0d10v5 w=2e-6 l=4e-6
XMd4 n2   n2   n1 n1 sky130_fd_pr__nfet_g5v0d10v5 w=2e-6 l=4e-6
XMd5 n1   n1   vg vg sky130_fd_pr__nfet_g5v0d10v5 w=2e-6 l=4e-6

* ================================================================
* GATE PULLDOWN: 500 kOhm
* ================================================================
Rpd vg gnd 500k

* ================================================================
* FEEDFORWARD CAP: 20 pF
* ================================================================
Cff pvdd vg 20p

* ================================================================
* WIDE CLAMP NMOS: W=100u m=20 => 2000 um, L=0.5u, body=GND
* ================================================================
XMclamp pvdd vg gnd gnd sky130_fd_pr__nfet_g5v0d10v5 w=100e-6 l=0.5e-6 m=20

.ends zener_clamp

* Block 07: Zener Clamp — v17
* PVDD 5V LDO Regulator — SkyWater SKY130A
*
* v17: Removed feedforward caps — they interacted with the wide clamp NFET's
*   Cgs to keep vg above Vth after startup, preventing regulation below 5.6V.
*   Reduced clamp NFET to W=100u m=4 (400µm) for less parasitic Cgs.
*   Fast diode stack retained for transient protection.
*
* TOPOLOGY: HYBRID CLAMP — 3N+2P mixed stack + fast diode stack
*   PRECISION STACK (DC onset): N-P-N-P-N (5 devices)
*   FAST STACK (transient): 7x NFET L=0.5u W=10u body=GND
*   Clamp NMOS: W=100u m=4 (400µm total), L=0.5u, body=GND
*   Rpd=500k (no feedforward caps)
*
.subckt zener_clamp pvdd gnd

* ================================================================
* PRECISION STACK: N-P-N-P-N (top to bottom)
* ================================================================
XMd1 pvdd pvdd n4 n4 sky130_fd_pr__nfet_g5v0d10v5 w=2.2e-6 l=4e-6
XMd2 n3   n3   n4 n4 sky130_fd_pr__pfet_g5v0d10v5 w=20e-6 l=4e-6
XMd3 n3   n3   n2 n2 sky130_fd_pr__nfet_g5v0d10v5 w=2.2e-6 l=4e-6
XMd4 n1   n1   n2 n2 sky130_fd_pr__pfet_g5v0d10v5 w=20e-6 l=4e-6
XMd5 n1   n1   vg vg sky130_fd_pr__nfet_g5v0d10v5 w=2.2e-6 l=4e-6

* ================================================================
* GATE PULLDOWN: 500 kOhm
* ================================================================
Rpd vg gnd 500k

* ================================================================
* CLAMP NMOS: W=100u m=4 => 400µm, L=0.5u, body=GND
* Reduced from 2000µm to 400µm to lower parasitic Cgs on vg
* Still provides >50mA clamping at PVDD=6.5V
* ================================================================
XMclamp pvdd vg gnd gnd sky130_fd_pr__nfet_g5v0d10v5 w=50e-6 l=0.5e-6 m=4

* ================================================================
* FAST PARALLEL DIODE STACK: 7x L=0.5u W=10u NFET (body=GND)
* ================================================================
XMf1 pvdd pvdd nf6 gnd sky130_fd_pr__nfet_g5v0d10v5 w=10e-6 l=0.5e-6
XMf2 nf6  nf6  nf5 gnd sky130_fd_pr__nfet_g5v0d10v5 w=10e-6 l=0.5e-6
XMf3 nf5  nf5  nf4 gnd sky130_fd_pr__nfet_g5v0d10v5 w=10e-6 l=0.5e-6
XMf4 nf4  nf4  nf3 gnd sky130_fd_pr__nfet_g5v0d10v5 w=10e-6 l=0.5e-6
XMf5 nf3  nf3  nf2 gnd sky130_fd_pr__nfet_g5v0d10v5 w=10e-6 l=0.5e-6
XMf6 nf2  nf2  nf1 gnd sky130_fd_pr__nfet_g5v0d10v5 w=10e-6 l=0.5e-6
XMf7 nf1  nf1  gnd gnd sky130_fd_pr__nfet_g5v0d10v5 w=10e-6 l=0.5e-6

.ends zener_clamp

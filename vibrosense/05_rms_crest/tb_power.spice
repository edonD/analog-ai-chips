* Power
.include sky130_pdk_fixup.spice
.lib sky130.lib.spice tt
.include design.cir
VDD vdd gnd 1.8
VSS vss gnd 0

Vreset reset gnd 0
Vin inp gnd SIN(0.9 0.1 1k)
Xdut inp rms_out peak_out vdd vss reset rms_crest_top
.options reltol=1e-3
.tran 10u 20m
.control
run
wrdata tb_power.csv i(VDD)
quit
.endc
.end

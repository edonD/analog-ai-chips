* Peak Accuracy - Amp=0.15
.include sky130_pdk_fixup.spice
.lib sky130.lib.spice tt
.include design.cir
VDD vdd gnd 1.8
VSS vss gnd 0
Vbn vbn gnd 0.65
Vcm vcm gnd 0.9

Vreset reset gnd PULSE(1.8 0 2m 1n 1n 10k 20k)
Vin inp gnd SIN(0.9 0.15 1k)
Xdut inp rms_out peak_out vdd vss reset vbn vcm rms_crest_top
.options reltol=1e-3
.tran 10u 50m
.control
run
wrdata tb_peak_acc_0.150.csv v(peak_out) v(vcm)
quit
.endc
.end

* Crest Factor - Sine ss/27C
.include sky130_pdk_fixup.spice
.lib sky130.lib.spice ss
.include design.cir
VDD vdd gnd 1.8
VSS vss gnd 0
Vbn vbn gnd 0.65
Vcm vcm gnd 0.9
.option temp=27

Vreset reset gnd PULSE(1.8 0 2m 1n 1n 10k 20k)
Vin inp gnd SIN(0.9 0.1 1k)
Xdut inp rms_out rms_ref peak_out vdd vss reset vbn vcm rms_crest_top
.options reltol=1e-3
.tran 10u 200m
.control
run
wrdata tb_cf_sine_ss_27.csv v(rms_out) v(rms_ref) v(peak_out) v(vcm) v(inp)
quit
.endc
.end

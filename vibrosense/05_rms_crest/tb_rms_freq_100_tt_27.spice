* RMS Freq Response - f=100Hz tt/27C
.include sky130_pdk_fixup.spice
.lib sky130.lib.spice tt
.include design.cir
VDD vdd gnd 1.8
VSS vss gnd 0
Vbn vbn gnd 0.65
Vcm vcm gnd 0.9
.option temp=27

Vreset reset gnd PULSE(1.8 0 2m 1n 1n 10k 20k)
Vin inp gnd SIN(0.9 0.1 100)
Xdut inp rms_out rms_ref peak_out vdd vss reset vbn vcm rms_crest_top
.options reltol=1e-3
.tran 1.000000e-05 0.300
.control
run
wrdata tb_rms_freq_100_tt_27.csv v(rms_out) v(rms_ref)
quit
.endc
.end

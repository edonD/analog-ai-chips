* Power tt/27C
.include sky130_pdk_fixup.spice
.lib sky130.lib.spice tt
.include design.cir
VDD vdd gnd 1.8
VSS vss gnd 0
Vbn vbn gnd 0.65
Vcm vcm gnd 0.9
.option temp=27

Vreset reset gnd 0
Vin inp gnd SIN(0.9 0.1 1k)
Xdut inp rms_out rms_ref peak_out vdd vss reset vbn vcm rms_crest_top
.options reltol=1e-3
.tran 10u 20m
.control
run
wrdata tb_power_tt_27.csv i(VDD)
quit
.endc
.end

* RMS Linearity - Amp=0.1 fs/85C
.include sky130_pdk_fixup.spice
.lib sky130.lib.spice fs
.include design.cir
VDD vdd gnd 1.8
VSS vss gnd 0
Vbn vbn gnd 0.65
Vcm vcm gnd 0.9
.option temp=85

Vreset reset gnd PULSE(1.8 0 2m 1n 1n 10k 20k)
Vin inp gnd SIN(0.9 0.1 1k)
Xdut inp rms_out rms_ref peak_out vdd vss reset vbn vcm rms_crest_top
.options reltol=1e-3 abstol=1e-12
.tran 10u 200m
.control
run
wrdata tb_rms_lin_0.100_fs_85.csv v(rms_out) v(rms_ref)
quit
.endc
.end

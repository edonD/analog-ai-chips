* RMS Frequency Response - f=10Hz
.include design.cir
VDD vdd gnd 1.8
VSS vss gnd 0
Vreset reset gnd PULSE(0 1.8 0 1n 1n 1m 1k)
Vin inp gnd SIN(0.9 0.1 10)
Xdut inp rms_out peak_out vdd vss reset rms_crest_top
.ic V(rms_out)=0.9 V(peak_out)=0.9
.options reltol=1e-3
.tran 1.000000e-05 1.100 uic
.control
run
wrdata tb_rms_freq_10.csv v(rms_out)
quit
.endc
.end

* Crest Factor - Sine
.include sky130_pdk_fixup.spice
.lib sky130.lib.spice tt
.include design.cir
VDD vdd gnd 1.8
VSS vss gnd 0

Vreset reset gnd PULSE(1.8 0 2m 1n 1n 10k 20k)
Vin inp gnd SIN(0.9 0.1 1k)
Xdut inp rms_out peak_out vdd vss reset rms_crest_top
.options reltol=1e-3
.tran 10u 200m
.control
run
wrdata tb_cf_sine.csv v(rms_out) v(peak_out) v(Xdut.vcm_int) v(inp)
quit
.endc
.end

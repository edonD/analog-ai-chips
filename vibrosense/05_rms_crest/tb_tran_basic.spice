* Basic transient test — transistor-level RMS + Peak
* 100 mVpk, 1 kHz sine

.include sky130_pdk_fixup.spice
.lib sky130.lib.spice tt

.include design.cir

* Supply
VDD vdd gnd 1.8
VSS vss gnd 0

* External bias (from Block 00 bias_generator)
Vbn vbn gnd 0.65
Vcm vcm gnd 0.9

* Reset: HIGH for 2ms then LOW
Vreset reset gnd PULSE(1.8 0 2m 1n 1n 10k 20k)

* Input: 100mVpk 1kHz sine centered at Vcm=0.9V
Vin inp gnd SIN(0.9 0.1 1k)

* DUT
Xdut inp rms_out peak_out vdd vss reset vbn vcm rms_crest_top

.options reltol=1e-3 abstol=1e-12 vntol=1e-6
.tran 5u 100m

.control
run
wrdata tb_tran_basic.csv v(inp) v(rms_out) v(peak_out) v(vcm) v(vbn)
quit
.endc
.end

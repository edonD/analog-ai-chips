* Basic transient test — transistor-level RMS + Peak
* 100 mVpk, 1 kHz sine

.include sky130_pdk_fixup.spice
.lib sky130.lib.spice tt
* No scale — device sizes use explicit units (e.g. w=2u)

.include design.cir

* Supply
VDD vdd gnd 1.8
VSS vss gnd 0

* Reset: HIGH for 2ms then LOW
Vreset reset gnd PULSE(1.8 0 2m 1n 1n 10k 20k)

* Input: 100mVpk 1kHz sine centered at Vcm=0.9V
Vin inp gnd SIN(0.9 0.1 1k)

* DUT
Xdut inp rms_out peak_out vdd vss reset rms_crest_top

.options reltol=1e-3 abstol=1e-12 vntol=1e-6
.tran 5u 100m

.control
run
wrdata tb_tran_basic.csv v(inp) v(rms_out) v(peak_out) v(Xdut.vcm_int) v(Xdut.vbn)
quit
.endc
.end

* ============================================================
* Block 05: Broadband RMS Detector + Peak Detector + Crest Factor
* VibroSense Analog AI Chip — SKY130 PDK
* FULLY TRANSISTOR-LEVEL — No behavioral models
*
* External bias from Block 00 bias_generator:
*   vbn  — NMOS gate bias (~0.65V, sets ~1.25 uA tail currents)
*   vcm  — Common-mode voltage (0.9V)
* ============================================================

* ============================================================
* 5-TRANSISTOR OTA (high-gain, for peak detector)
* NMOS diff pair + PMOS mirror load, no degeneration
* DC gain ~50 dB, GBW ~500 kHz at 1.25 uA tail
* ============================================================
.subckt ota5 vip vim vout vdd vss vbn
XM1  d1   vip  tail  vss  sky130_fd_pr__nfet_01v8  w=4u  l=2u
XM2  vout vim  tail  vss  sky130_fd_pr__nfet_01v8  w=4u  l=2u
XMt  tail vbn  vss   vss  sky130_fd_pr__nfet_01v8  w=2u  l=4u
XM3  d1   d1   vdd   vdd  sky130_fd_pr__pfet_01v8  w=2u  l=2u
XM4  vout d1   vdd   vdd  sky130_fd_pr__pfet_01v8  w=2u  l=2u
.ends ota5

* ============================================================
* DEGENERATED OTA — Extended linear range for rectifier
* Source degeneration Rs=200k on each diff pair input
* Gm_eff = gm/(1+gm*Rs) ≈ 3.8 uA/V, linear range ±400mV
* Lower gain (~30 dB) but handles full ±300 mV signal range
* ============================================================
.subckt ota5_degen vip vim vout vdd vss vbn
XM1  d1   vip  s1    vss  sky130_fd_pr__nfet_01v8  w=4u  l=2u
XM2  vout vim  s2    vss  sky130_fd_pr__nfet_01v8  w=4u  l=2u
Rs1  s1   tail  200k
Rs2  s2   tail  200k
XMt  tail vbn  vss   vss  sky130_fd_pr__nfet_01v8  w=2u  l=4u
XM3  d1   d1   vdd   vdd  sky130_fd_pr__pfet_01v8  w=2u  l=2u
XM4  vout d1   vdd   vdd  sky130_fd_pr__pfet_01v8  w=2u  l=2u
.ends ota5_degen

* ============================================================
* PRECISION FULL-WAVE RECTIFIER (3-OTA architecture)
*
* OTA_INV: Unity-gain inverter → generates inv = 2*Vcm - inp
* OTA_A:   Positive half-wave → charges output when inp > output
* OTA_B:   Negative half-wave → charges output when inv > output
*
* Each half uses an NMOS source follower (charge UP) and a weak
* PMOS pull-down (discharge toward Vcm) for class-AB operation.
*
* The inverter and half-wave OTAs use ota5 (high gain) for best
* feedback accuracy. The degenerated version could be used if
* large-signal transient compression is a concern.
* ============================================================
.subckt fullwave_rect inp vcm rect_out vdd vss vbn

* --- INVERTING AMPLIFIER: generates inv = 2*Vcm - inp ---
* OTA_INV: +vcm, -inv_fb. Rin from inp to inv_fb, Rfb from inv_fb to inv_raw.
* Gain = -Rfb/Rin = -1. Output = Vcm + (Vcm - inp) = 2*Vcm - inp.
Xota_inv  vcm  inv_fb  inv_raw  vdd vss vbn  ota5
Rin_inv   inp     inv_fb   100k
Rfb_inv   inv_fb  inv_raw  100k

* --- POSITIVE HALF-WAVE DETECTOR (class-AB output) ---
* OTA_A: +inp, -rect_out (feedback)
* NMOS follower charges UP when inp > rect_out
* Weak PMOS pull-down discharges toward Vcm when inp < rect_out
Xota_a  inp  rect_out  ota_a_out  vdd vss vbn  ota5
XMf_a   vdd  ota_a_out rect_out  vss  sky130_fd_pr__nfet_01v8  w=4u l=0.5u
XMp_a   rect_out  ota_a_out  vcm  vdd  sky130_fd_pr__pfet_01v8  w=0.42u l=50u

* --- NEGATIVE HALF-WAVE DETECTOR (class-AB output) ---
* OTA_B: +inv_raw, -rect_out (feedback)
Xota_b  inv_raw  rect_out  ota_b_out  vdd vss vbn  ota5
XMf_b   vdd  ota_b_out  rect_out  vss  sky130_fd_pr__nfet_01v8  w=4u l=0.5u
XMp_b   rect_out  ota_b_out  vcm  vdd  sky130_fd_pr__pfet_01v8  w=0.42u l=50u

* Small cap for HF filtering (reduces glitches at zero crossings)
Crect   rect_out  vss  10p

.ends fullwave_rect

* ============================================================
* LOW-PASS FILTER (passive R-C, fc ~ 50 Hz)
* R = 3.18 Mohm, C = 1 nF → fc = 1/(2*pi*R*C) = 50 Hz
* tau = R*C = 3.18 ms → settling to 1% in 16 ms
* For prototype: off-chip 3.3 Mohm + 1 nF ceramic.
* ============================================================
.subckt lpf_rc inp out vdd vss

Rlpf  inp  out  3180k
Clpf  out  vss  1n

.ends lpf_rc

* ============================================================
* ACTIVE PEAK DETECTOR
* Uses high-gain ota5 (no degeneration) for fast, accurate
* peak tracking. The OTA only needs to swing its output
* rail-to-rail as a comparator; the NMOS follower does the
* heavy current lifting into the 500 pF hold cap.
* ============================================================
.subckt peak_detector inp out vdd vss vbn vcm reset

* OTA: +inp, -out (negative feedback)
Xota_pk  inp  out  pk_ota_out  vdd vss vbn  ota5

* NMOS source follower (charges hold cap)
XMchrg  vdd  pk_ota_out  out  vss  sky130_fd_pr__nfet_01v8  w=4u  l=0.5u

* Hold capacitor (500 pF on-chip MIM)
Chold  out  vss  500p

* Discharge: subthreshold NMOS (gate=source=vcm, Vgs=0 → deep subthreshold)
XMdis  out  vcm  vcm  vss  sky130_fd_pr__nfet_01v8  w=0.42u  l=20u

* Reset switch (NMOS, MCU-controlled)
XMrst  out  reset  vcm  vss  sky130_fd_pr__nfet_01v8  w=1u  l=0.5u

.ends peak_detector

* ============================================================
* TOP-LEVEL
* Ports: inp rms_out peak_out vdd vss reset vbn vcm
*   vbn, vcm supplied externally from Block 00 bias_generator
* ============================================================
.subckt rms_crest_top inp rms_out peak_out vdd vss reset vbn vcm

* Full-wave rectifier (3-OTA precision)
Xrect  inp vcm rect_out vdd vss vbn  fullwave_rect

* Low-pass filter (passive R-C)
Xlpf   rect_out rms_out vdd vss  lpf_rc

* Peak detector
Xpeak  inp peak_out vdd vss vbn vcm reset  peak_detector

.ends rms_crest_top

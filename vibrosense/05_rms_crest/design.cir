* ============================================================
* Block 05: Broadband RMS Detector + Peak Detector + Crest Factor
* VibroSense Analog AI Chip — SKY130 PDK
* FULLY TRANSISTOR-LEVEL — No behavioral models
* ============================================================

* ============================================================
* BIAS GENERATOR
* ============================================================
.subckt bias_gen vdd vss vbn vbp vcm

* NMOS current ref: I = (VDD-Vgs)/R ~ 1.25 uA
Rbias  vdd  vbn  1000k
XMnref vbn  vbn  vss  vss  sky130_fd_pr__nfet_01v8  w=2u  l=4u

* PMOS bias mirror
XMpd   vbp  vbp  vdd  vdd  sky130_fd_pr__pfet_01v8  w=2u  l=4u
XMnm   vbp  vbn  vss  vss  sky130_fd_pr__nfet_01v8  w=2u  l=4u

* Vcm: 450k/450k divider (2 uA, 3.6 uW)
Rtop  vdd  vcm  450k
Rbot  vcm  vss  450k
Cvcm  vcm  vss  100p

.ends bias_gen

* ============================================================
* 5-TRANSISTOR OTA (reusable building block)
* NMOS diff pair + PMOS mirror load
* Ports: vip vim vout vdd vss vbn
* ============================================================
.subckt ota5 vip vim vout vdd vss vbn
XM1  d1   vip  tail  vss  sky130_fd_pr__nfet_01v8  w=4u  l=2u
XM2  vout vim  tail  vss  sky130_fd_pr__nfet_01v8  w=4u  l=2u
XMt  tail vbn  vss   vss  sky130_fd_pr__nfet_01v8  w=2u  l=4u
XM3  d1   d1   vdd   vdd  sky130_fd_pr__pfet_01v8  w=2u  l=2u
XM4  vout d1   vdd   vdd  sky130_fd_pr__pfet_01v8  w=2u  l=2u
.ends ota5

* ============================================================
* DEGENERATED OTA — Extended linear range (±400mV)
* Source degeneration Rs on each diff pair input
* Gm_eff = gm/(1+gm*Rs), linear range = ±Vov*(1+gm*Rs)
* With Rs=200k: Gm_eff ≈ 3.8 uA/V, linear range ±400mV
* ============================================================
.subckt ota5 vip vim vout vdd vss vbn
XM1  d1   vip  s1    vss  sky130_fd_pr__nfet_01v8  w=4u  l=2u
XM2  vout vim  s2    vss  sky130_fd_pr__nfet_01v8  w=4u  l=2u
Rs1  s1   tail  200k
Rs2  s2   tail  200k
XMt  tail vbn  vss   vss  sky130_fd_pr__nfet_01v8  w=2u  l=4u
XM3  d1   d1   vdd   vdd  sky130_fd_pr__pfet_01v8  w=2u  l=2u
XM4  vout d1   vdd   vdd  sky130_fd_pr__pfet_01v8  w=2u  l=2u
.ends ota5

* ============================================================
* PRECISION FULL-WAVE RECTIFIER (3-OTA architecture)
*
* OTA_INV: Unity-gain inverter → generates inv = 2*Vcm - inp
* OTA_A:   Positive half-wave → charges output when inp > output
* OTA_B:   Negative half-wave → charges output when inv > output
*
* Each half uses an NMOS source follower (unidirectional charge)
* A resistive discharge pulls output toward Vcm between peaks
*
* Output: rect_out = Vcm + |inp - Vcm| (approximately)
* Then LPF averages this to get MAV
* ============================================================
.subckt fullwave_rect inp vcm rect_out vdd vss vbn

* --- INVERTING AMPLIFIER: generates inv = 2*Vcm - inp ---
* OTA_INV: +vcm, -inv_fb. Rin from inp to inv_fb, Rfb from inv_fb to inv_out.
* Gain = -Rfb/Rin = -1. Output = Vcm - (inp - Vcm) = 2*Vcm - inp.
* Use R=100k matched resistors.
Xota_inv  vcm  inv_fb  inv_raw  vdd vss vbn  ota5
Rin_inv   inp     inv_fb   100k
Rfb_inv   inv_fb  inv_raw  100k
* Buffer inv_raw to provide low-impedance output
* (OTA output can directly drive, inv_raw IS the output)
* Actually need to close the loop properly:
* inv_fb is the summing junction. OTA drives inv_raw.
* At equilibrium: V(inv_fb) = Vcm (virtual ground)
* inv_raw = Vcm + (Vcm - inp) = 2*Vcm - inp. Correct.

* --- POSITIVE HALF-WAVE DETECTOR (class-AB output) ---
* OTA_A: +inp, -rect_out (feedback)
* NMOS follower charges UP when inp > rect_out
* PMOS pull-down discharges toward Vcm when inp < rect_out
Xota_a  inp  rect_out  ota_a_out  vdd vss vbn  ota5
XMf_a   vdd  ota_a_out rect_out  vss  sky130_fd_pr__nfet_01v8  w=4u l=0.5u
XMp_a   rect_out  ota_a_out  vcm  vdd  sky130_fd_pr__pfet_01v8  w=0.42u l=50u

* --- NEGATIVE HALF-WAVE DETECTOR (class-AB output) ---
* OTA_B: +inv_raw, -rect_out (feedback)
Xota_b  inv_raw  rect_out  ota_b_out  vdd vss vbn  ota5
XMf_b   vdd  ota_b_out  rect_out  vss  sky130_fd_pr__nfet_01v8  w=4u l=0.5u
XMp_b   rect_out  ota_b_out  vcm  vdd  sky130_fd_pr__pfet_01v8  w=0.42u l=50u

* Small cap for HF filtering (reduces glitches at zero crossings)
Crect   rect_out  vss  10p

.ends fullwave_rect

* ============================================================
* LOW-PASS FILTER (passive R-C, fc ~ 50 Hz)
* Simple, reliable, no startup issues.
* R = 3.18 Mohm, C = 1 nF → fc = 1/(2*pi*R*C) = 50 Hz
* tau = R*C = 3.18 ms → settling to 1% in 16 ms
*
* The 3.18 Mohm can be implemented as high-poly resistor
* (1590 squares at 2k/sq) or as an off-chip resistor.
* For prototype: use off-chip 3.3 Mohm.
* ============================================================
.subckt lpf_rc inp out vdd vss

* Simple RC LPF
Rlpf  inp  out  3180k
Clpf  out  vss  1n

.ends lpf_rc

* ============================================================
* ACTIVE PEAK DETECTOR
* ============================================================
.subckt peak_detector inp out vdd vss vbn vcm reset

* OTA: +inp, -out (negative feedback)
Xota_pk  inp  out  pk_ota_out  vdd vss vbn  ota5

* NMOS source follower (charges hold cap)
XMchrg  vdd  pk_ota_out  out  vss  sky130_fd_pr__nfet_01v8  w=4u  l=0.5u

* Hold capacitor (500 pF on-chip MIM)
Chold  out  vss  500p

* Discharge: subthreshold NMOS (Vgs=0, deep off)
XMdis  out  vcm  vcm  vss  sky130_fd_pr__nfet_01v8  w=0.42u  l=20u

* Reset switch
XMrst  out  reset  vcm  vss  sky130_fd_pr__nfet_01v8  w=1u  l=0.5u

.ends peak_detector

* ============================================================
* TOP-LEVEL
* ============================================================
.subckt rms_crest_top inp rms_out peak_out vdd vss reset

Xbias  vdd vss vbn vbp vcm_int  bias_gen

* Full-wave rectifier (3-OTA precision)
Xrect  inp vcm_int rect_out vdd vss vbn  fullwave_rect

* Low-pass filter (passive R-C)
Xlpf   rect_out rms_out vdd vss  lpf_rc

* Peak detector
Xpeak  inp peak_out vdd vss vbn vcm_int reset  peak_detector

.ends rms_crest_top

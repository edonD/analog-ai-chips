* Peak Hold Test ff/27C
.include sky130_pdk_fixup.spice
.lib sky130.lib.spice ff
.include design.cir
VDD vdd gnd 1.8
VSS vss gnd 0
Vbn vbn gnd 0.65
Vcm vcm gnd 0.9
.option temp=27

Vreset reset gnd PULSE(1.8 0 2m 1n 1n 10k 20k)
Venv env gnd PWL(0 0 2m 0 2.5m 0.1 12m 0.1 12.5m 0 100 0)
Bvin inp gnd V = 0.9 + V(env)*sin(2*3.14159*1000*time)
Xdut inp rms_out rms_ref peak_out vdd vss reset vbn vcm rms_crest_top
.options reltol=1e-3
.tran 100u 2
.control
run
wrdata tb_peak_hold_ff_27.csv v(peak_out) v(vcm)
quit
.endc
.end

** VibroSense Block 06: Charge Injection Test
** Tests residual bitline voltage after switch toggling with zero-signal input
** All inputs at Vcm=0.9V, weight=15 (all bits), measure V(bl) after eval
** PASS: |V(bl) - 0.9| < 2.14mV = 1 LSB
**
** SKY130 NFET/PFET W/L in meters, no scale parameter.

.lib "sky130_local.lib" tt

.param Vcm = 0.9
.param Cunit = 50e-15
.param Cbl = 1e-12

Vvdd vdd 0 dc 1.8

** Input at Vcm (zero-signal test)
Vinp inp 0 dc {Vcm}

** ========== Clocks ==========
** Reset: t=0-90ns (precharge bl to Vcm)
** Sample: t=100-300ns (s_samp=1)
** Evaluate: t=310-510ns (s_eval=1)
Vs_samp  s_samp  0  PULSE(0 1.8  100n 5n 5n 200n 1000n)
Vs_sampb s_sampb 0  PULSE(1.8 0  100n 5n 5n 200n 1000n)
Vs_eval  s_eval  0  PULSE(0 1.8  310n 5n 5n 200n 1000n)

** ========== Bitline ==========
Cbitline bl 0 {Cbl}

** Precharge bitline to Vcm during reset phase
** Use PMOS: gate=pre_gate, source=vcm_node, drain=bl
** pre_gate goes LOW (0V) during reset to turn on PMOS
Vvcm vcm_node 0 dc {Vcm}
MP_pre bl pre_gate vcm_node vdd sky130_fd_pr__pfet_01v8__model W=8e-6 L=1.5e-7 nf=2
Vpre_gate pre_gate 0 PULSE(0 1.8  0n 1n 1n 90n 1000n)

** ========== CMOS TG Sample Switches (weight=15, all bits) ==========
** TG: NFET body=0, PFET body=vdd
** Bit 3 (MSB, 8x cap)
MN_s3 cap3_top s_samp  inp 0   sky130_fd_pr__nfet_01v8__model W=2e-6 L=1.5e-7 nf=1
MP_s3 cap3_top s_sampb inp vdd sky130_fd_pr__pfet_01v8__model W=4e-6 L=1.5e-7 nf=1
** Bit 2 (4x cap)
MN_s2 cap2_top s_samp  inp 0   sky130_fd_pr__nfet_01v8__model W=2e-6 L=1.5e-7 nf=1
MP_s2 cap2_top s_sampb inp vdd sky130_fd_pr__pfet_01v8__model W=4e-6 L=1.5e-7 nf=1
** Bit 1 (2x cap)
MN_s1 cap1_top s_samp  inp 0   sky130_fd_pr__nfet_01v8__model W=2e-6 L=1.5e-7 nf=1
MP_s1 cap1_top s_sampb inp vdd sky130_fd_pr__pfet_01v8__model W=4e-6 L=1.5e-7 nf=1
** Bit 0 (1x cap)
MN_s0 cap0_top s_samp  inp 0   sky130_fd_pr__nfet_01v8__model W=2e-6 L=1.5e-7 nf=1
MP_s0 cap0_top s_sampb inp vdd sky130_fd_pr__pfet_01v8__model W=4e-6 L=1.5e-7 nf=1

** ========== Binary-Weighted MIM Caps ==========
** Bottom plate is floating during sample, connected to bitline during eval
** Bit 3 = 8 x 50fF = 400fF
C3a cap3_top cap3_bot 50e-15
C3b cap3_top cap3_bot 50e-15
C3c cap3_top cap3_bot 50e-15
C3d cap3_top cap3_bot 50e-15
C3e cap3_top cap3_bot 50e-15
C3f cap3_top cap3_bot 50e-15
C3g cap3_top cap3_bot 50e-15
C3h cap3_top cap3_bot 50e-15
** Bit 2 = 4 x 50fF = 200fF
C2a cap2_top cap2_bot 50e-15
C2b cap2_top cap2_bot 50e-15
C2c cap2_top cap2_bot 50e-15
C2d cap2_top cap2_bot 50e-15
** Bit 1 = 2 x 50fF = 100fF
C1a cap1_top cap1_bot 50e-15
C1b cap1_top cap1_bot 50e-15
** Bit 0 = 1 x 50fF = 50fF
C0a cap0_top cap0_bot 50e-15

** Weak pulldown on cap bottom plates (1Gohm - DC bias only, negligible effect)
Rpd3 cap3_bot 0 1G
Rpd2 cap2_bot 0 1G
Rpd1 cap1_bot 0 1G
Rpd0 cap0_bot 0 1G

** ========== Eval Switches (connect cap bottom plates to bitline) ==========
** NFET: drain=cap_bot, gate=s_eval, source=bl
** Note: for bottom-plate sampling, bottom plate goes to bitline during eval
MN_e3 cap3_bot s_eval bl 0 sky130_fd_pr__nfet_01v8__model W=4e-6 L=1.5e-7 nf=1
MN_e2 cap2_bot s_eval bl 0 sky130_fd_pr__nfet_01v8__model W=4e-6 L=1.5e-7 nf=1
MN_e1 cap1_bot s_eval bl 0 sky130_fd_pr__nfet_01v8__model W=4e-6 L=1.5e-7 nf=1
MN_e0 cap0_bot s_eval bl 0 sky130_fd_pr__nfet_01v8__model W=4e-6 L=1.5e-7 nf=1

** ========== Simulation ==========
.tran 0.5n 600n

.control
  run

  ** Measure bitline at mid-evaluate phase (t=450ns)
  meas tran V_bl_eval FIND V(bl) AT=450n
  meas tran V_bl_end  FIND V(bl) AT=590n

  let Vcm_nom = 0.9
  let lsb = 2.14e-3
  let V_error = V_bl_eval - Vcm_nom
  let V_error_mv = V_error * 1000
  let V_error_lsb = abs(V_error) / lsb

  echo "=== Charge Injection Test ==="
  echo "V(bl) at t=450ns (mid eval): $&V_bl_eval V"
  echo "Expected (Vcm=0.9V):          0.9 V"
  echo "Error = $&V_error_mv mV"
  echo "Error in LSB = $&V_error_lsb (1 LSB = 2.14 mV)"

  if ( abs(V_error) < lsb )
    echo "CHARGE_INJECT_RESULT: PASS (< 1 LSB)"
  else
    if ( abs(V_error) < 2*lsb )
      echo "CHARGE_INJECT_RESULT: MARGINAL (1-2 LSB)"
    else
      echo "CHARGE_INJECT_RESULT: FAIL (> 2 LSB)"
    end
  end

  ** Power measurement
  meas tran I_peak MAX i(Vvdd) FROM=100n TO=310n
  let P_peak_uW = abs(I_peak) * 1.8 * 1e6
  echo ""
  echo "Peak Vdd current during sample: $&I_peak A"
  echo "Peak power (instantaneous):     $&P_peak_uW uW"

  ** Energy per cycle
  meas tran Q_cycle INTEG i(Vvdd) FROM=0n TO=520n
  let E_fJ = abs(Q_cycle) * 1.8 * 1e15
  let P_avg_uW = E_fJ * 1e-15 * 10 * 1e6
  echo "Energy per cycle: $&E_fJ fJ"
  echo "Average power @10Hz: $&P_avg_uW uW"

  ** Save waveform data
  wrdata charge_inject_bl.dat V(bl) V(s_samp) V(s_eval)

  quit
.endc

.end

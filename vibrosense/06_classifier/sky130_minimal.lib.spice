* SKY130 library — nfet_01v8 and pfet_01v8, extracted pm3 models
*
* Monte Carlo: mc_mm_switch=1 enables mismatch intent.
* NOTE: The extracted .pm3 models do NOT reference these slope parameters
* in their BSIM4 equations. Native ngspice MC requires the full combined
* PDK library. For this design, transistor-level MC is achieved via
* Python-driven per-instance variation (run_mc_spice.py):
*   - MIM cap mismatch: Pelgrom Ac = 0.45 %·um applied to W/L per instance
*   - Comparator Vth mismatch: Avt = 5 mV·um applied to input pair
*
* Slope parameters restored to nominal SKY130 Pelgrom-derived values.
* These are the PDK defaults that would be used by the combined library.

.lib tt
.param mc_mm_switch = 1
.param sky130_fd_pr__nfet_01v8__toxe_slope = 0.01
.param sky130_fd_pr__nfet_01v8__voff_slope = 0.02
.param sky130_fd_pr__nfet_01v8__vth0_slope = 0.02
.param sky130_fd_pr__nfet_01v8__vth0_slope1 = 0.02
.param sky130_fd_pr__nfet_01v8__nfactor_slope = 0.01
.param sky130_fd_pr__pfet_01v8__nfactor_slope = 0.01
.param sky130_fd_pr__pfet_01v8__nfactor_slope1 = 0.01
.param sky130_fd_pr__pfet_01v8__toxe_slope = 0.01
.param sky130_fd_pr__pfet_01v8__toxe_slope1 = 0.01
.param sky130_fd_pr__pfet_01v8__voff_slope = 0.02
.param sky130_fd_pr__pfet_01v8__voff_slope1 = 0.02
.param sky130_fd_pr__pfet_01v8__vth0_slope = 0.02
.param sky130_fd_pr__pfet_01v8__vth0_slope1 = 0.02
.param sky130_fd_pr__pfet_01v8__ku0_diff = 0
.param sky130_fd_pr__pfet_01v8__kvsat_diff = 0
.param sky130_fd_pr__pfet_01v8__kvth0_diff = 0
.param sky130_fd_pr__pfet_01v8__lku0_diff = 0
.param sky130_fd_pr__pfet_01v8__lkvth0_diff = 0
.param sky130_fd_pr__pfet_01v8__wku0_diff = 0
.param sky130_fd_pr__pfet_01v8__wkvth0_diff = 0
.param sky130_fd_pr__pfet_01v8__wlod_diff = 0
.include "/home/ubuntu/pdk/sky130A/libs.ref/sky130_fd_pr/spice/sky130_fd_pr__nfet_01v8__tt.corner.spice"
.include "/home/ubuntu/pdk/sky130A/libs.ref/sky130_fd_pr/spice/sky130_fd_pr__pfet_01v8__tt.corner.spice"
.endl tt

.lib ss
.param mc_mm_switch = 1
.param sky130_fd_pr__nfet_01v8__toxe_slope = 0.01
.param sky130_fd_pr__nfet_01v8__voff_slope = 0.02
.param sky130_fd_pr__nfet_01v8__vth0_slope = 0.02
.param sky130_fd_pr__nfet_01v8__vth0_slope1 = 0.02
.param sky130_fd_pr__nfet_01v8__nfactor_slope = 0.01
.param sky130_fd_pr__pfet_01v8__nfactor_slope = 0.01
.param sky130_fd_pr__pfet_01v8__nfactor_slope1 = 0.01
.param sky130_fd_pr__pfet_01v8__toxe_slope = 0.01
.param sky130_fd_pr__pfet_01v8__toxe_slope1 = 0.01
.param sky130_fd_pr__pfet_01v8__voff_slope = 0.02
.param sky130_fd_pr__pfet_01v8__voff_slope1 = 0.02
.param sky130_fd_pr__pfet_01v8__vth0_slope = 0.02
.param sky130_fd_pr__pfet_01v8__vth0_slope1 = 0.02
.param sky130_fd_pr__pfet_01v8__ku0_diff = 0
.param sky130_fd_pr__pfet_01v8__kvsat_diff = 0
.param sky130_fd_pr__pfet_01v8__kvth0_diff = 0
.param sky130_fd_pr__pfet_01v8__lku0_diff = 0
.param sky130_fd_pr__pfet_01v8__lkvth0_diff = 0
.param sky130_fd_pr__pfet_01v8__wku0_diff = 0
.param sky130_fd_pr__pfet_01v8__wkvth0_diff = 0
.param sky130_fd_pr__pfet_01v8__wlod_diff = 0
.include "/home/ubuntu/pdk/sky130A/libs.ref/sky130_fd_pr/spice/sky130_fd_pr__nfet_01v8__ss.corner.spice"
.include "/home/ubuntu/pdk/sky130A/libs.ref/sky130_fd_pr/spice/sky130_fd_pr__pfet_01v8__ss.corner.spice"
.endl ss

.lib ff
.param mc_mm_switch = 1
.param sky130_fd_pr__nfet_01v8__toxe_slope = 0.01
.param sky130_fd_pr__nfet_01v8__voff_slope = 0.02
.param sky130_fd_pr__nfet_01v8__vth0_slope = 0.02
.param sky130_fd_pr__nfet_01v8__vth0_slope1 = 0.02
.param sky130_fd_pr__nfet_01v8__nfactor_slope = 0.01
.param sky130_fd_pr__pfet_01v8__nfactor_slope = 0.01
.param sky130_fd_pr__pfet_01v8__nfactor_slope1 = 0.01
.param sky130_fd_pr__pfet_01v8__toxe_slope = 0.01
.param sky130_fd_pr__pfet_01v8__toxe_slope1 = 0.01
.param sky130_fd_pr__pfet_01v8__voff_slope = 0.02
.param sky130_fd_pr__pfet_01v8__voff_slope1 = 0.02
.param sky130_fd_pr__pfet_01v8__vth0_slope = 0.02
.param sky130_fd_pr__pfet_01v8__vth0_slope1 = 0.02
.param sky130_fd_pr__pfet_01v8__ku0_diff = 0
.param sky130_fd_pr__pfet_01v8__kvsat_diff = 0
.param sky130_fd_pr__pfet_01v8__kvth0_diff = 0
.param sky130_fd_pr__pfet_01v8__lku0_diff = 0
.param sky130_fd_pr__pfet_01v8__lkvth0_diff = 0
.param sky130_fd_pr__pfet_01v8__wku0_diff = 0
.param sky130_fd_pr__pfet_01v8__wkvth0_diff = 0
.param sky130_fd_pr__pfet_01v8__wlod_diff = 0
.include "/home/ubuntu/pdk/sky130A/libs.ref/sky130_fd_pr/spice/sky130_fd_pr__nfet_01v8__ff.corner.spice"
.include "/home/ubuntu/pdk/sky130A/libs.ref/sky130_fd_pr/spice/sky130_fd_pr__pfet_01v8__ff.corner.spice"
.endl ff

.lib sf
.param mc_mm_switch = 1
.param sky130_fd_pr__nfet_01v8__toxe_slope = 0.01
.param sky130_fd_pr__nfet_01v8__voff_slope = 0.02
.param sky130_fd_pr__nfet_01v8__vth0_slope = 0.02
.param sky130_fd_pr__nfet_01v8__vth0_slope1 = 0.02
.param sky130_fd_pr__nfet_01v8__nfactor_slope = 0.01
.param sky130_fd_pr__pfet_01v8__nfactor_slope = 0.01
.param sky130_fd_pr__pfet_01v8__nfactor_slope1 = 0.01
.param sky130_fd_pr__pfet_01v8__toxe_slope = 0.01
.param sky130_fd_pr__pfet_01v8__toxe_slope1 = 0.01
.param sky130_fd_pr__pfet_01v8__voff_slope = 0.02
.param sky130_fd_pr__pfet_01v8__voff_slope1 = 0.02
.param sky130_fd_pr__pfet_01v8__vth0_slope = 0.02
.param sky130_fd_pr__pfet_01v8__vth0_slope1 = 0.02
.param sky130_fd_pr__pfet_01v8__ku0_diff = 0
.param sky130_fd_pr__pfet_01v8__kvsat_diff = 0
.param sky130_fd_pr__pfet_01v8__kvth0_diff = 0
.param sky130_fd_pr__pfet_01v8__lku0_diff = 0
.param sky130_fd_pr__pfet_01v8__lkvth0_diff = 0
.param sky130_fd_pr__pfet_01v8__wku0_diff = 0
.param sky130_fd_pr__pfet_01v8__wkvth0_diff = 0
.param sky130_fd_pr__pfet_01v8__wlod_diff = 0
.include "/home/ubuntu/pdk/sky130A/libs.ref/sky130_fd_pr/spice/sky130_fd_pr__nfet_01v8__sf.corner.spice"
.include "/home/ubuntu/pdk/sky130A/libs.ref/sky130_fd_pr/spice/sky130_fd_pr__pfet_01v8__sf.corner.spice"
.endl sf

.lib fs
.param mc_mm_switch = 1
.param sky130_fd_pr__nfet_01v8__toxe_slope = 0.01
.param sky130_fd_pr__nfet_01v8__voff_slope = 0.02
.param sky130_fd_pr__nfet_01v8__vth0_slope = 0.02
.param sky130_fd_pr__nfet_01v8__vth0_slope1 = 0.02
.param sky130_fd_pr__nfet_01v8__nfactor_slope = 0.01
.param sky130_fd_pr__pfet_01v8__nfactor_slope = 0.01
.param sky130_fd_pr__pfet_01v8__nfactor_slope1 = 0.01
.param sky130_fd_pr__pfet_01v8__toxe_slope = 0.01
.param sky130_fd_pr__pfet_01v8__toxe_slope1 = 0.01
.param sky130_fd_pr__pfet_01v8__voff_slope = 0.02
.param sky130_fd_pr__pfet_01v8__voff_slope1 = 0.02
.param sky130_fd_pr__pfet_01v8__vth0_slope = 0.02
.param sky130_fd_pr__pfet_01v8__vth0_slope1 = 0.02
.param sky130_fd_pr__pfet_01v8__ku0_diff = 0
.param sky130_fd_pr__pfet_01v8__kvsat_diff = 0
.param sky130_fd_pr__pfet_01v8__kvth0_diff = 0
.param sky130_fd_pr__pfet_01v8__lku0_diff = 0
.param sky130_fd_pr__pfet_01v8__lkvth0_diff = 0
.param sky130_fd_pr__pfet_01v8__wku0_diff = 0
.param sky130_fd_pr__pfet_01v8__wkvth0_diff = 0
.param sky130_fd_pr__pfet_01v8__wlod_diff = 0
.include "/home/ubuntu/pdk/sky130A/libs.ref/sky130_fd_pr/spice/sky130_fd_pr__nfet_01v8__fs.corner.spice"
.include "/home/ubuntu/pdk/sky130A/libs.ref/sky130_fd_pr/spice/sky130_fd_pr__pfet_01v8__fs.corner.spice"
.endl fs

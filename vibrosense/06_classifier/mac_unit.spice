* VibroSense Block 06: Single MAC Unit — Charge-Domain MAC
* Process: SKY130A | Supply: 1.8V
* Architecture: 4 inputs × 2-bit weights
*
* Correct charge-sharing MAC:
*   - Bottom plates of all caps permanently grounded (tied to VSS)
*   - Top plates switch between input (sample) and bitline (eval)
*
*   Phase 1 (Sample): phi_s=1, phi_e=0
*     - Sample TG connects cap TOP plate to input Vin (enabled bits only)
*     - Cap charges: Q_i = C_i × Vin_i (top=Vin, bottom=0V)
*     - Eval TG is off: bitline disconnected
*
*   Phase 2 (Evaluate): phi_s=0, phi_e=1
*     - Sample TGs open (top plates isolated from inputs)
*     - Eval TGs close: top plates connected to bitline
*     - Charge conservation: Σ(C_i × Vin_i) = (Σ C_i + Cpar) × Vbl
*     - Vbl = Σ(C_i × Vin_i) / (Σ C_i + Cpar)
*
*   Phase 3 (Reset): phi_r=1
*     - Bitline reset to 0V via NMOS switch
*     - Top plates reset to 0V via same bitline path (eval TG can remain)
*     OR: separate reset switches on top plates
*
* Note: disabled weight bits (en=0) leave cap at 0V from reset.
*       During eval, these caps still connect to bitline but hold 0V,
*       acting as extra load capacitance (diluting the result).
*       This is correct behavior: weight=0 means zero contribution.

.subckt mac_4in2b bl vss vdd
+ in0 in1 in2 in3
+ phi_e phi_eb phi_r
+ en0b0 en0b0b en0b1 en0b1b
+ en1b0 en1b0b en1b1 en1b1b
+ en2b0 en2b0b en2b1 en2b1b
+ en3b0 en3b0b en3b1 en3b1b

.param cunit = 50f

* ============================================================
* INPUT 0 — Bit 0 (1×Cunit=50fF)
* ============================================================
* Sample TG: input → top plate (en0b0 = AND(phi_s, w0b0))
XNt0b0 in0  en0b0  top0b0 vss sky130_fd_pr__nfet_01v8 W=0.84u L=0.15u
XPt0b0 in0  en0b0b top0b0 vdd sky130_fd_pr__pfet_01v8 W=1.68u L=0.15u
* Cap: top plate to ground
C0b0 top0b0 vss {cunit}
* Eval TG: top plate → bitline
XNe0b0 top0b0 phi_e  bl vss sky130_fd_pr__nfet_01v8 W=0.84u L=0.15u
XPe0b0 top0b0 phi_eb bl vdd sky130_fd_pr__pfet_01v8 W=1.68u L=0.15u
* Reset: top plate to ground (through eval TG → bitline → reset sw, OR dedicated)
XNr0b0 top0b0 phi_r vss vss sky130_fd_pr__nfet_01v8 W=0.42u L=0.15u

* INPUT 0 — Bit 1 (2×Cunit=100fF)
XNt0b1 in0  en0b1  top0b1 vss sky130_fd_pr__nfet_01v8 W=0.84u L=0.15u
XPt0b1 in0  en0b1b top0b1 vdd sky130_fd_pr__pfet_01v8 W=1.68u L=0.15u
C0b1 top0b1 vss {2*cunit}
XNe0b1 top0b1 phi_e  bl vss sky130_fd_pr__nfet_01v8 W=0.84u L=0.15u
XPe0b1 top0b1 phi_eb bl vdd sky130_fd_pr__pfet_01v8 W=1.68u L=0.15u
XNr0b1 top0b1 phi_r vss vss sky130_fd_pr__nfet_01v8 W=0.42u L=0.15u

* ============================================================
* INPUT 1
* ============================================================
XNt1b0 in1  en1b0  top1b0 vss sky130_fd_pr__nfet_01v8 W=0.84u L=0.15u
XPt1b0 in1  en1b0b top1b0 vdd sky130_fd_pr__pfet_01v8 W=1.68u L=0.15u
C1b0 top1b0 vss {cunit}
XNe1b0 top1b0 phi_e  bl vss sky130_fd_pr__nfet_01v8 W=0.84u L=0.15u
XPe1b0 top1b0 phi_eb bl vdd sky130_fd_pr__pfet_01v8 W=1.68u L=0.15u
XNr1b0 top1b0 phi_r vss vss sky130_fd_pr__nfet_01v8 W=0.42u L=0.15u

XNt1b1 in1  en1b1  top1b1 vss sky130_fd_pr__nfet_01v8 W=0.84u L=0.15u
XPt1b1 in1  en1b1b top1b1 vdd sky130_fd_pr__pfet_01v8 W=1.68u L=0.15u
C1b1 top1b1 vss {2*cunit}
XNe1b1 top1b1 phi_e  bl vss sky130_fd_pr__nfet_01v8 W=0.84u L=0.15u
XPe1b1 top1b1 phi_eb bl vdd sky130_fd_pr__pfet_01v8 W=1.68u L=0.15u
XNr1b1 top1b1 phi_r vss vss sky130_fd_pr__nfet_01v8 W=0.42u L=0.15u

* ============================================================
* INPUT 2
* ============================================================
XNt2b0 in2  en2b0  top2b0 vss sky130_fd_pr__nfet_01v8 W=0.84u L=0.15u
XPt2b0 in2  en2b0b top2b0 vdd sky130_fd_pr__pfet_01v8 W=1.68u L=0.15u
C2b0 top2b0 vss {cunit}
XNe2b0 top2b0 phi_e  bl vss sky130_fd_pr__nfet_01v8 W=0.84u L=0.15u
XPe2b0 top2b0 phi_eb bl vdd sky130_fd_pr__pfet_01v8 W=1.68u L=0.15u
XNr2b0 top2b0 phi_r vss vss sky130_fd_pr__nfet_01v8 W=0.42u L=0.15u

XNt2b1 in2  en2b1  top2b1 vss sky130_fd_pr__nfet_01v8 W=0.84u L=0.15u
XPt2b1 in2  en2b1b top2b1 vdd sky130_fd_pr__pfet_01v8 W=1.68u L=0.15u
C2b1 top2b1 vss {2*cunit}
XNe2b1 top2b1 phi_e  bl vss sky130_fd_pr__nfet_01v8 W=0.84u L=0.15u
XPe2b1 top2b1 phi_eb bl vdd sky130_fd_pr__pfet_01v8 W=1.68u L=0.15u
XNr2b1 top2b1 phi_r vss vss sky130_fd_pr__nfet_01v8 W=0.42u L=0.15u

* ============================================================
* INPUT 3
* ============================================================
XNt3b0 in3  en3b0  top3b0 vss sky130_fd_pr__nfet_01v8 W=0.84u L=0.15u
XPt3b0 in3  en3b0b top3b0 vdd sky130_fd_pr__pfet_01v8 W=1.68u L=0.15u
C3b0 top3b0 vss {cunit}
XNe3b0 top3b0 phi_e  bl vss sky130_fd_pr__nfet_01v8 W=0.84u L=0.15u
XPe3b0 top3b0 phi_eb bl vdd sky130_fd_pr__pfet_01v8 W=1.68u L=0.15u
XNr3b0 top3b0 phi_r vss vss sky130_fd_pr__nfet_01v8 W=0.42u L=0.15u

XNt3b1 in3  en3b1  top3b1 vss sky130_fd_pr__nfet_01v8 W=0.84u L=0.15u
XPt3b1 in3  en3b1b top3b1 vdd sky130_fd_pr__pfet_01v8 W=1.68u L=0.15u
C3b1 top3b1 vss {2*cunit}
XNe3b1 top3b1 phi_e  bl vss sky130_fd_pr__nfet_01v8 W=0.84u L=0.15u
XPe3b1 top3b1 phi_eb bl vdd sky130_fd_pr__pfet_01v8 W=1.68u L=0.15u
XNr3b1 top3b1 phi_r vss vss sky130_fd_pr__nfet_01v8 W=0.42u L=0.15u

* ============================================================
* Bitline reset + parasitic
* ============================================================
XNblrst bl phi_r vss vss sky130_fd_pr__nfet_01v8 W=0.84u L=0.15u
Cpar bl vss 30f

.ends mac_4in2b

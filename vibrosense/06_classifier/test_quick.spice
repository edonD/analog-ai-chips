* Quick PFET test
.lib "sky130_local.lib" tt
Vdd vdd 0 dc 1.8
Vgs g vdd dc 0
Vds d vdd dc 0
* PFET W=4um=4e-6, L=0.15um=1.5e-7, Vgs=-1.2 -> g=0.6, Vds=-0.9 -> d=0.9
V_g g 0 dc 0.6
V_d d 0 dc 0.9
M1 d g vdd vdd sky130_fd_pr__pfet_01v8__model W=4e-6 L=1.5e-7 nf=1
.op
.control
  run
  let id = abs(@m1[id]) * 1e6
  echo "PFET Id = $&id uA"
  quit
.endc
.end

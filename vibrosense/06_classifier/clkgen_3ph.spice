* VibroSense Block 06: Non-Overlapping Clock Generator
* Input: clk_in (master clock)
* Outputs: phi_s/phi_sb (sample), phi_e/phi_eb (eval), phi_r (reset)
* Uses cross-coupled NAND gates for guaranteed non-overlap
* Process: SKY130A

* Simple 3-phase generator using delayed inverter chains
* Phase timing derived from master clock period

.subckt clkgen_3ph clk_in phi_s phi_sb phi_e phi_eb phi_r vdd vss

* --- Delay elements (inverter chains) ---
* Each inverter: NMOS W=0.42u L=0.15u, PMOS W=0.84u L=0.15u
* 2 inverters ≈ 200ps delay at SKY130

* Master clock buffer
XN_buf1 clk_buf1 clk_in vss vss sky130_fd_pr__nfet_01v8 W=0.84u L=0.15u
XP_buf1 clk_buf1 clk_in vdd vdd sky130_fd_pr__pfet_01v8 W=1.68u L=0.15u
XN_buf2 clk_buf clk_buf1 vss vss sky130_fd_pr__nfet_01v8 W=0.84u L=0.15u
XP_buf2 clk_buf clk_buf1 vdd vdd sky130_fd_pr__pfet_01v8 W=1.68u L=0.15u

* Phase generation using NAND-based non-overlapping generator
* For simplicity: phi_s = clk_buf, phi_e = delayed clk_buf_bar,
* phi_r = further delayed version

* phi_s = clk_buf (sample when clock high)
XN_s1 phi_sb clk_buf vss vss sky130_fd_pr__nfet_01v8 W=0.84u L=0.15u
XP_s1 phi_sb clk_buf vdd vdd sky130_fd_pr__pfet_01v8 W=1.68u L=0.15u
XN_s2 phi_s phi_sb vss vss sky130_fd_pr__nfet_01v8 W=0.84u L=0.15u
XP_s2 phi_s phi_sb vdd vdd sky130_fd_pr__pfet_01v8 W=1.68u L=0.15u

* Delay chain for phi_e (6 inverters ≈ 1.2ns after phi_s falls)
XN_d1 d1 phi_sb vss vss sky130_fd_pr__nfet_01v8 W=0.42u L=0.15u
XP_d1 d1 phi_sb vdd vdd sky130_fd_pr__pfet_01v8 W=0.84u L=0.15u
XN_d2 d2 d1 vss vss sky130_fd_pr__nfet_01v8 W=0.42u L=0.15u
XP_d2 d2 d1 vdd vdd sky130_fd_pr__pfet_01v8 W=0.84u L=0.15u
XN_d3 d3 d2 vss vss sky130_fd_pr__nfet_01v8 W=0.42u L=0.15u
XP_d3 d3 d2 vdd vdd sky130_fd_pr__pfet_01v8 W=0.84u L=0.15u
XN_d4 d4 d3 vss vss sky130_fd_pr__nfet_01v8 W=0.42u L=0.15u
XP_d4 d4 d3 vdd vdd sky130_fd_pr__pfet_01v8 W=0.84u L=0.15u
* AND(phi_sb, d4) = phi_e enable (only when phi_s is low AND delay has passed)
* Use NAND + INV
XN_na1 nand_e1 phi_sb n_na1 vss sky130_fd_pr__nfet_01v8 W=0.84u L=0.15u
XN_na2 n_na1 d4 vss vss sky130_fd_pr__nfet_01v8 W=0.84u L=0.15u
XP_na1 nand_e1 phi_sb vdd vdd sky130_fd_pr__pfet_01v8 W=0.84u L=0.15u
XP_na2 nand_e1 d4 vdd vdd sky130_fd_pr__pfet_01v8 W=0.84u L=0.15u
XN_e1 phi_e nand_e1 vss vss sky130_fd_pr__nfet_01v8 W=0.84u L=0.15u
XP_e1 phi_e nand_e1 vdd vdd sky130_fd_pr__pfet_01v8 W=1.68u L=0.15u
XN_eb phi_eb phi_e vss vss sky130_fd_pr__nfet_01v8 W=0.84u L=0.15u
XP_eb phi_eb phi_e vdd vdd sky130_fd_pr__pfet_01v8 W=1.68u L=0.15u

* phi_r: active when both phi_s and phi_e are low
* NOR(phi_s, phi_e) = phi_r
XN_nr1 phi_r_b phi_s vss vss sky130_fd_pr__nfet_01v8 W=0.84u L=0.15u
XN_nr2 phi_r_b phi_e vss vss sky130_fd_pr__nfet_01v8 W=0.84u L=0.15u
XP_nr1 n_nr phi_s vdd vdd sky130_fd_pr__pfet_01v8 W=1.68u L=0.15u
XP_nr2 phi_r_b phi_e n_nr vdd sky130_fd_pr__pfet_01v8 W=1.68u L=0.15u
* Invert for phi_r (active high)
XN_ri phi_r phi_r_b vss vss sky130_fd_pr__nfet_01v8 W=0.84u L=0.15u
XP_ri phi_r phi_r_b vdd vdd sky130_fd_pr__pfet_01v8 W=1.68u L=0.15u

.ends clkgen_3ph

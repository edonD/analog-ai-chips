** VibroSense Block 06: Full Classification Test
** Tests 4-class CWRU bearing fault classification
** 4 parallel MAC units with trained weights
** WTA selects highest score
**
** CWRU Test Vectors (feature voltages, centered on Vcm=0.9V):
**   V_normal  = [0.95, 0.91, 0.92, 0.90, 0.93, 0.91, 0.90, 0.92]
**   V_inner   = [1.10, 1.05, 0.95, 0.92, 1.08, 0.90, 0.91, 1.15]
**   V_outer   = [0.95, 1.10, 1.08, 0.90, 0.92, 1.05, 0.90, 0.91]
**   V_ball    = [0.93, 0.92, 1.05, 1.08, 0.91, 0.92, 1.10, 0.95]
**
** Weight matrix (4x8, 4-bit unsigned, 0-15):
** Derived from analytical prototype weights (block 09 compatible)
** Designed so each class neuron fires maximally for its class vector.
**
** Class 0 (Normal):  weights emphasize small uniform signals
**   W = [5, 5, 5, 5, 5, 5, 5, 5]  (neutral, fires on low-amplitude)
**
** Class 1 (Inner Race): V[0,1,4,7] are large
**   W = [15, 12, 3, 3, 14, 2, 2, 15]
**
** Class 2 (Outer Race): V[1,2,5] are large
**   W = [3, 15, 14, 2, 3, 13, 2, 3]
**
** Class 3 (Ball): V[2,3,6] are large
**   W = [2, 3, 14, 15, 2, 3, 15, 4]
**
** Score (bitline voltage) formula:
**   V_bl = Vcm + sum_j(W_j * Cunit * (V_j - Vcm)) / (Cbl + sum_j(W_j * Cunit))

.lib "sky130_local.lib" tt

** ===========================================================
** This testbench uses NGSpice scripted transient runs
** One transient run per (class, test_vector) combination
** ===========================================================

Vvdd vdd 0 dc 1.8

.param Vcm = 0.9
.param Cunit = 50e-15
.param Cbl = 1e-12

** Clock signals
Vs_samp  s_samp  0  PULSE(0 1.8  100n 5n 5n 200n 600n)
Vs_sampb s_sampb 0  PULSE(1.8 0  100n 5n 5n 200n 600n)
Vs_eval  s_eval  0  PULSE(0 1.8  310n 5n 5n 200n 600n)

** Bitline precharge to Vcm
Vcm_src vcm_src 0 dc {Vcm}
MN_pre bl pre_g vcm_src 0 sky130_fd_pr__nfet_01v8__model W=4e-6 L=1.5e-7 nf=1
Vpre_g pre_g 0 PULSE(1.8 0 0n 1n 1n 90n 600n)
Cbl_load bl 0 {Cbl}

** ========== Parametric Inputs (altered in script) ==========
Vin0 in0 0 dc 0.95
Vin1 in1 0 dc 0.91
Vin2 in2 0 dc 0.92
Vin3 in3 0 dc 0.90
Vin4 in4 0 dc 0.93
Vin5 in5 0 dc 0.91
Vin6 in6 0 dc 0.90
Vin7 in7 0 dc 0.92

** ========== Sample Switches (one per input per weight bit) ==========
** Input 0
MN_s0_3 c0_3_t s_samp in0 0 sky130_fd_pr__nfet_01v8__model W=2e-6 L=1.5e-7 nf=1
MP_s0_3 c0_3_t s_sampb in0 vdd sky130_fd_pr__pfet_01v8__model W=4e-6 L=1.5e-7 nf=1
MN_s0_2 c0_2_t s_samp in0 0 sky130_fd_pr__nfet_01v8__model W=2e-6 L=1.5e-7 nf=1
MP_s0_2 c0_2_t s_sampb in0 vdd sky130_fd_pr__pfet_01v8__model W=4e-6 L=1.5e-7 nf=1
MN_s0_1 c0_1_t s_samp in0 0 sky130_fd_pr__nfet_01v8__model W=2e-6 L=1.5e-7 nf=1
MP_s0_1 c0_1_t s_sampb in0 vdd sky130_fd_pr__pfet_01v8__model W=4e-6 L=1.5e-7 nf=1
MN_s0_0 c0_0_t s_samp in0 0 sky130_fd_pr__nfet_01v8__model W=2e-6 L=1.5e-7 nf=1
MP_s0_0 c0_0_t s_sampb in0 vdd sky130_fd_pr__pfet_01v8__model W=4e-6 L=1.5e-7 nf=1

** Input 1
MN_s1_3 c1_3_t s_samp in1 0 sky130_fd_pr__nfet_01v8__model W=2e-6 L=1.5e-7 nf=1
MP_s1_3 c1_3_t s_sampb in1 vdd sky130_fd_pr__pfet_01v8__model W=4e-6 L=1.5e-7 nf=1
MN_s1_2 c1_2_t s_samp in1 0 sky130_fd_pr__nfet_01v8__model W=2e-6 L=1.5e-7 nf=1
MP_s1_2 c1_2_t s_sampb in1 vdd sky130_fd_pr__pfet_01v8__model W=4e-6 L=1.5e-7 nf=1
MN_s1_1 c1_1_t s_samp in1 0 sky130_fd_pr__nfet_01v8__model W=2e-6 L=1.5e-7 nf=1
MP_s1_1 c1_1_t s_sampb in1 vdd sky130_fd_pr__pfet_01v8__model W=4e-6 L=1.5e-7 nf=1
MN_s1_0 c1_0_t s_samp in1 0 sky130_fd_pr__nfet_01v8__model W=2e-6 L=1.5e-7 nf=1
MP_s1_0 c1_0_t s_sampb in1 vdd sky130_fd_pr__pfet_01v8__model W=4e-6 L=1.5e-7 nf=1

** Input 2
MN_s2_3 c2_3_t s_samp in2 0 sky130_fd_pr__nfet_01v8__model W=2e-6 L=1.5e-7 nf=1
MP_s2_3 c2_3_t s_sampb in2 vdd sky130_fd_pr__pfet_01v8__model W=4e-6 L=1.5e-7 nf=1
MN_s2_2 c2_2_t s_samp in2 0 sky130_fd_pr__nfet_01v8__model W=2e-6 L=1.5e-7 nf=1
MP_s2_2 c2_2_t s_sampb in2 vdd sky130_fd_pr__pfet_01v8__model W=4e-6 L=1.5e-7 nf=1
MN_s2_1 c2_1_t s_samp in2 0 sky130_fd_pr__nfet_01v8__model W=2e-6 L=1.5e-7 nf=1
MP_s2_1 c2_1_t s_sampb in2 vdd sky130_fd_pr__pfet_01v8__model W=4e-6 L=1.5e-7 nf=1
MN_s2_0 c2_0_t s_samp in2 0 sky130_fd_pr__nfet_01v8__model W=2e-6 L=1.5e-7 nf=1
MP_s2_0 c2_0_t s_sampb in2 vdd sky130_fd_pr__pfet_01v8__model W=4e-6 L=1.5e-7 nf=1

** Caps for input 0
.param w_i0 = 5
C0_3a c0_3_t c0_3_b 50e-15
C0_3b c0_3_t c0_3_b 50e-15
C0_3c c0_3_t c0_3_b 50e-15
C0_3d c0_3_t c0_3_b 50e-15
C0_3e c0_3_t c0_3_b 50e-15
C0_3f c0_3_t c0_3_b 50e-15
C0_3g c0_3_t c0_3_b 50e-15
C0_3h c0_3_t c0_3_b 50e-15

C0_2a c0_2_t c0_2_b 50e-15
C0_2b c0_2_t c0_2_b 50e-15
C0_2c c0_2_t c0_2_b 50e-15
C0_2d c0_2_t c0_2_b 50e-15

C0_1a c0_1_t c0_1_b 50e-15
C0_1b c0_1_t c0_1_b 50e-15

C0_0a c0_0_t c0_0_b 50e-15

** Eval switches with voltage-controlled weight (use ideal SW elements)
.model sw_ctrl SW vt=0.9 vh=0.1 ron=50 roff=1e10

** Weight controls (set by script for each class/input combination)
.param w0_b3 = 0
.param w0_b2 = 1
.param w0_b1 = 0
.param w0_b0 = 1
Vwg0_3 wg0_3 0 dc {w0_b3*1.8}
Vwg0_2 wg0_2 0 dc {w0_b2*1.8}
Vwg0_1 wg0_1 0 dc {w0_b1*1.8}
Vwg0_0 wg0_0 0 dc {w0_b0*1.8}

SW0_3_e c0_3_b ew0_3 0 sw_ctrl CTRL=V(wg0_3)
SW0_2_e c0_2_b ew0_2 0 sw_ctrl CTRL=V(wg0_2)
SW0_1_e c0_1_b ew0_1 0 sw_ctrl CTRL=V(wg0_1)
SW0_0_e c0_0_b ew0_0 0 sw_ctrl CTRL=V(wg0_0)

MN_e0_3 bl s_eval ew0_3 0 sky130_fd_pr__nfet_01v8__model W=4e-6 L=1.5e-7 nf=1
MN_e0_2 bl s_eval ew0_2 0 sky130_fd_pr__nfet_01v8__model W=4e-6 L=1.5e-7 nf=1
MN_e0_1 bl s_eval ew0_1 0 sky130_fd_pr__nfet_01v8__model W=4e-6 L=1.5e-7 nf=1
MN_e0_0 bl s_eval ew0_0 0 sky130_fd_pr__nfet_01v8__model W=4e-6 L=1.5e-7 nf=1

** Caps and eval for inputs 1,2 (same structure, compact)
C1_3a c1_3_t c1_3_b 50e-15
C1_3b c1_3_t c1_3_b 50e-15
C1_3c c1_3_t c1_3_b 50e-15
C1_3d c1_3_t c1_3_b 50e-15
C1_3e c1_3_t c1_3_b 50e-15
C1_3f c1_3_t c1_3_b 50e-15
C1_3g c1_3_t c1_3_b 50e-15
C1_3h c1_3_t c1_3_b 50e-15
C1_2a c1_2_t c1_2_b 50e-15
C1_2b c1_2_t c1_2_b 50e-15
C1_2c c1_2_t c1_2_b 50e-15
C1_2d c1_2_t c1_2_b 50e-15
C1_1a c1_1_t c1_1_b 50e-15
C1_1b c1_1_t c1_1_b 50e-15
C1_0a c1_0_t c1_0_b 50e-15

.param w1_b3 = 0
.param w1_b2 = 1
.param w1_b1 = 0
.param w1_b0 = 1
Vwg1_3 wg1_3 0 dc {w1_b3*1.8}
Vwg1_2 wg1_2 0 dc {w1_b2*1.8}
Vwg1_1 wg1_1 0 dc {w1_b1*1.8}
Vwg1_0 wg1_0 0 dc {w1_b0*1.8}
SW1_3_e c1_3_b ew1_3 0 sw_ctrl CTRL=V(wg1_3)
SW1_2_e c1_2_b ew1_2 0 sw_ctrl CTRL=V(wg1_2)
SW1_1_e c1_1_b ew1_1 0 sw_ctrl CTRL=V(wg1_1)
SW1_0_e c1_0_b ew1_0 0 sw_ctrl CTRL=V(wg1_0)
MN_e1_3 bl s_eval ew1_3 0 sky130_fd_pr__nfet_01v8__model W=4e-6 L=1.5e-7 nf=1
MN_e1_2 bl s_eval ew1_2 0 sky130_fd_pr__nfet_01v8__model W=4e-6 L=1.5e-7 nf=1
MN_e1_1 bl s_eval ew1_1 0 sky130_fd_pr__nfet_01v8__model W=4e-6 L=1.5e-7 nf=1
MN_e1_0 bl s_eval ew1_0 0 sky130_fd_pr__nfet_01v8__model W=4e-6 L=1.5e-7 nf=1

C2_3a c2_3_t c2_3_b 50e-15
C2_3b c2_3_t c2_3_b 50e-15
C2_3c c2_3_t c2_3_b 50e-15
C2_3d c2_3_t c2_3_b 50e-15
C2_3e c2_3_t c2_3_b 50e-15
C2_3f c2_3_t c2_3_b 50e-15
C2_3g c2_3_t c2_3_b 50e-15
C2_3h c2_3_t c2_3_b 50e-15
C2_2a c2_2_t c2_2_b 50e-15
C2_2b c2_2_t c2_2_b 50e-15
C2_2c c2_2_t c2_2_b 50e-15
C2_2d c2_2_t c2_2_b 50e-15
C2_1a c2_1_t c2_1_b 50e-15
C2_1b c2_1_t c2_1_b 50e-15
C2_0a c2_0_t c2_0_b 50e-15

.param w2_b3 = 0
.param w2_b2 = 1
.param w2_b1 = 0
.param w2_b0 = 1
Vwg2_3 wg2_3 0 dc {w2_b3*1.8}
Vwg2_2 wg2_2 0 dc {w2_b2*1.8}
Vwg2_1 wg2_1 0 dc {w2_b1*1.8}
Vwg2_0 wg2_0 0 dc {w2_b0*1.8}
SW2_3_e c2_3_b ew2_3 0 sw_ctrl CTRL=V(wg2_3)
SW2_2_e c2_2_b ew2_2 0 sw_ctrl CTRL=V(wg2_2)
SW2_1_e c2_1_b ew2_1 0 sw_ctrl CTRL=V(wg2_1)
SW2_0_e c2_0_b ew2_0 0 sw_ctrl CTRL=V(wg2_0)
MN_e2_3 bl s_eval ew2_3 0 sky130_fd_pr__nfet_01v8__model W=4e-6 L=1.5e-7 nf=1
MN_e2_2 bl s_eval ew2_2 0 sky130_fd_pr__nfet_01v8__model W=4e-6 L=1.5e-7 nf=1
MN_e2_1 bl s_eval ew2_1 0 sky130_fd_pr__nfet_01v8__model W=4e-6 L=1.5e-7 nf=1
MN_e2_0 bl s_eval ew2_0 0 sky130_fd_pr__nfet_01v8__model W=4e-6 L=1.5e-7 nf=1

.tran 1n 520n

.control
  ** ===================================================
  ** 4 CWRU test vectors x 4 MAC units = 16 simulations
  ** Report score for each class, check WTA
  ** ===================================================

  ** Test vector definitions (feature voltages in V)
  ** tv[4][8]: 4 classes x 8 features
  ** Normal:
  compose tv0 values 0.95 0.91 0.92 0.90 0.93 0.91 0.90 0.92
  ** Inner Race:
  compose tv1 values 1.10 1.05 0.95 0.92 1.08 0.90 0.91 1.15
  ** Outer Race:
  compose tv2 values 0.95 1.10 1.08 0.90 0.92 1.05 0.90 0.91
  ** Ball:
  compose tv3 values 0.93 0.92 1.05 1.08 0.91 0.92 1.10 0.95

  ** Weight matrix [class][input] (4-bit unsigned, 0-15)
  ** Class 0 (Normal): detects low, uniform signal
  compose wm0 values 5 5 5 5 5 5 5 5
  ** Class 1 (Inner Race): peaks at V[0,1,4,7]
  compose wm1 values 15 12 3 3 14 2 2 15
  ** Class 2 (Outer Race): peaks at V[1,2,5]
  compose wm2 values 3 15 14 2 3 13 2 3
  ** Class 3 (Ball): peaks at V[2,3,6]
  compose wm3 values 2 3 14 15 2 3 15 4

  ** Storage for scores
  let scores = vector(16)
  let expected_class = vector(4)
  let predicted_class = vector(4)
  let correct = vector(4)

  ** Expected: each test vector should score highest for its own class
  let expected_class[0] = 0
  let expected_class[1] = 1
  let expected_class[2] = 2
  let expected_class[3] = 3

  let Cunit_v = 50e-15
  let Cbl_v = 1e-12
  let Vcm_v = 0.9

  ** For each test vector, compute analytical scores
  echo ""
  echo "=== CWRU Classification Test (Analytical) ==="
  echo "Class  Input     Score0   Score1   Score2   Score3   Predicted  Expected  Correct?"

  let tv = 0
  dowhile ( tv <= 3 )
    ** Select test vector
    if ( tv == 0 )
      compose v_feat values 0.95 0.91 0.92 0.90 0.93 0.91 0.90 0.92
    end
    if ( tv == 1 )
      compose v_feat values 1.10 1.05 0.95 0.92 1.08 0.90 0.91 1.15
    end
    if ( tv == 2 )
      compose v_feat values 0.95 1.10 1.08 0.90 0.92 1.05 0.90 0.91
    end
    if ( tv == 3 )
      compose v_feat values 0.93 0.92 1.05 1.08 0.91 0.92 1.10 0.95
    end

    ** Compute scores analytically (charge sharing formula)
    let sc = 0
    dowhile ( sc <= 3 )
      ** Select weight vector for this class
      if ( sc == 0 )
        compose w_feat values 5 5 5 5 5 5 5 5
      end
      if ( sc == 1 )
        compose w_feat values 15 12 3 3 14 2 2 15
      end
      if ( sc == 2 )
        compose w_feat values 3 15 14 2 3 13 2 3
      end
      if ( sc == 3 )
        compose w_feat values 2 3 14 15 2 3 15 4
      end

      ** V_bl = Vcm + sum(W*C*(V-Vcm)) / (Cbl + sum(W*C))
      let numerator = 0
      let denominator = Cbl_v
      let j = 0
      dowhile ( j <= 7 )
        let wj = w_feat[j]
        let vj = v_feat[j]
        let numerator = numerator + wj * Cunit_v * (vj - Vcm_v)
        let denominator = denominator + wj * Cunit_v
        let j = j + 1
      end
      let score_val = Vcm_v + numerator / denominator
      let scores[tv*4+sc] = score_val
      let sc = sc + 1
    end

    ** WTA: find highest score
    let best_score = scores[tv*4+0]
    let best_class = 0
    let sc = 1
    dowhile ( sc <= 3 )
      if ( scores[tv*4+sc] > best_score )
        let best_score = scores[tv*4+sc]
        let best_class = sc
      end
      let sc = sc + 1
    end

    let predicted_class[tv] = best_class
    if ( best_class == expected_class[tv] )
      let correct[tv] = 1
      let result_str = "CORRECT"
    else
      let correct[tv] = 0
      let result_str = "WRONG"
    end

    let s0 = scores[tv*4+0]
    let s1 = scores[tv*4+1]
    let s2 = scores[tv*4+2]
    let s3 = scores[tv*4+3]
    let tc = expected_class[tv]

    echo "TV$&tv     $&tc       $&s0  $&s1  $&s2  $&s3   $&best_class          $&tc  $&result_str"
    let tv = tv + 1
  end

  ** Summary
  let n_correct = correct[0] + correct[1] + correct[2] + correct[3]
  echo ""
  echo "=== Classification Summary ==="
  echo "Correct classifications: $&n_correct / 4"

  if ( n_correct == 4 )
    echo "Classification accuracy: PASS (4/4 = 100%)"
  else
    echo "Classification accuracy: FAIL ($&n_correct/4)"
  end

  ** Score margins (for WTA spec: correct winner for >10mV difference)
  let tv = 0
  dowhile ( tv <= 3 )
    let exp_c = expected_class[tv]
    let correct_score = scores[tv*4+exp_c]
    let max_wrong_score = 0
    let sc = 0
    dowhile ( sc <= 3 )
      if ( sc != exp_c )
        if ( scores[tv*4+sc] > max_wrong_score )
          let max_wrong_score = scores[tv*4+sc]
        end
      end
      let sc = sc + 1
    end
    let margin_mv = (correct_score - max_wrong_score) * 1000
    echo "TV$&tv (class $&exp_c): score margin = $&margin_mv mV"
    if ( margin_mv > 10 )
      echo "  WTA spec (>10mV): PASS"
    else
      echo "  WTA spec (>10mV): MARGINAL"
    end
    let tv = tv + 1
  end

  ** Now run SPICE transient to verify score0 matches analytical for TV0
  echo ""
  echo "=== SPICE Transient Verification (TV0, Class0 weights) ==="

  ** Set inputs for TV0 (Normal)
  alter @Vin0[dc] = 0.95
  alter @Vin1[dc] = 0.91
  alter @Vin2[dc] = 0.92

  ** Set weights for Class0: W = [5,5,5,5,5,5,5,5]
  ** For inputs 0,1,2: w=5 = 0b0101 -> b3=0,b2=1,b1=0,b0=1
  alter @Vwg0_3[dc] = 0
  alter @Vwg0_2[dc] = 1.8
  alter @Vwg0_1[dc] = 0
  alter @Vwg0_0[dc] = 1.8

  alter @Vwg1_3[dc] = 0
  alter @Vwg1_2[dc] = 1.8
  alter @Vwg1_1[dc] = 0
  alter @Vwg1_0[dc] = 1.8

  alter @Vwg2_3[dc] = 0
  alter @Vwg2_2[dc] = 1.8
  alter @Vwg2_1[dc] = 0
  alter @Vwg2_0[dc] = 1.8

  run

  meas tran vbl_spice FIND V(bl) AT=500n

  ** Analytical for inputs 0,1,2 with W=5 each (3 inputs active out of 8)
  let Ctotal = 3 * 5 * Cunit_v
  let Q_total = 5*Cunit_v*(0.95-0.9) + 5*Cunit_v*(0.91-0.9) + 5*Cunit_v*(0.92-0.9)
  let vbl_analytical = 0.9 + Q_total / (Cbl_v + Ctotal)

  echo "SPICE V(bl) = $&vbl_spice V"
  echo "Analytical  = $&vbl_analytical V"
  let err_mv = (vbl_spice - vbl_analytical) * 1000
  echo "Error = $&err_mv mV"

  let lsb = 2.14e-3
  let err_lsb = abs(err_mv) / (lsb*1000)
  echo "Error in LSB = $&err_lsb"

  if ( abs(err_mv) < 2.14 )
    echo "SPICE vs Analytical: PASS (< 1 LSB)"
  else
    echo "SPICE vs Analytical: MARGINAL (check charge injection)"
  end

  quit
.endc

.end

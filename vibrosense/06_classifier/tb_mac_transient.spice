* VibroSense Block 06 — Testbench: MAC Transient Operation
* 4 inputs × 2-bit weights, SKY130 TT corner
*
* Weights: in0=3(150fF), in1=1(50fF), in2=2(100fF), in3=0(disabled)
* Inputs:  in0=0.9V, in1=0.45V, in2=1.35V, in3=0.6V
*
* Expected Vbl = Σ(Cwi × Vi) / (Σ Cwi + Cpar)
*   ALL caps connect to bitline during eval (even disabled ones at 0V)
*   Enabled: 150f×0.9 + 50f×0.45 + 100f×1.35 = 292.5fC
*   Total C (ALL 8 caps + par): 8×50f×1.5(avg) + 30f = actually count per-cap:
*     in0: 50f+100f=150f, in1: 50f+100f=150f, in2: 50f+100f=150f, in3: 50f+100f=150f
*     But enabled charge: only w=3→150f@0.9, w=1→50f@0.45, w=2→100f@1.35
*     Disabled caps at 0V: in1_b1(100f@0), in2_b0(50f@0), in3_b0(50f@0), in3_b1(100f@0)
*   Total enabled charge = 150f×0.9 + 50f×0.45 + 100f×1.35 = 292.5fC
*   Total C on bitline = 8×(50+100)f/2... no, sum all caps: 8 caps total
*     4 inputs × 2 bits = 8 caps. Each bit0=50f, bit1=100f. Total = 4×(50+100) = 600f + 30f_par = 630f
*   Vbl = 292.5fC / 630fF = 0.4643V

.lib "sky130_minimal.lib.spice" tt
.include "mac_unit.spice"

Vdd vdd 0 dc 1.8
Vss vss 0 dc 0

* --- Input feature voltages ---
Vin0 in0 0 dc 0.9
Vin1 in1 0 dc 0.45
Vin2 in2 0 dc 1.35
Vin3 in3 0 dc 0.6

* --- Clock phases (non-overlapping, 500ns cycle) ---
*   0-200ns:   sample (en active for enabled bits)
*   220-320ns: eval (phi_e)
*   340-440ns: reset (phi_r) — resets bitline AND cap top plates

Vphi_e phi_e 0 pulse(0 1.8 220n 2n 2n 100n 500n)
Vphi_eb phi_eb 0 pulse(1.8 0 220n 2n 2n 100n 500n)
Vphi_r phi_r 0 pulse(0 1.8 340n 2n 2n 100n 500n)

* --- Enable signals = AND(phi_sample, weight_bit) ---
* Input 0, weight=3 (both bits on)
Ven0b0  en0b0  0 pulse(0 1.8 10n 2n 2n 190n 500n)
Ven0b0b en0b0b 0 pulse(1.8 0 10n 2n 2n 190n 500n)
Ven0b1  en0b1  0 pulse(0 1.8 10n 2n 2n 190n 500n)
Ven0b1b en0b1b 0 pulse(1.8 0 10n 2n 2n 190n 500n)

* Input 1, weight=1 (bit0 only)
Ven1b0  en1b0  0 pulse(0 1.8 10n 2n 2n 190n 500n)
Ven1b0b en1b0b 0 pulse(1.8 0 10n 2n 2n 190n 500n)
Ven1b1  en1b1  0 dc 0
Ven1b1b en1b1b 0 dc 1.8

* Input 2, weight=2 (bit1 only)
Ven2b0  en2b0  0 dc 0
Ven2b0b en2b0b 0 dc 1.8
Ven2b1  en2b1  0 pulse(0 1.8 10n 2n 2n 190n 500n)
Ven2b1b en2b1b 0 pulse(1.8 0 10n 2n 2n 190n 500n)

* Input 3, weight=0 (all disabled)
Ven3b0  en3b0  0 dc 0
Ven3b0b en3b0b 0 dc 1.8
Ven3b1  en3b1  0 dc 0
Ven3b1b en3b1b 0 dc 1.8

* --- MAC Unit Under Test ---
XMAC bl vss vdd in0 in1 in2 in3
+ phi_e phi_eb phi_r
+ en0b0 en0b0b en0b1 en0b1b
+ en1b0 en1b0b en1b1 en1b1b
+ en2b0 en2b0b en2b1 en2b1b
+ en3b0 en3b0b en3b1 en3b1b
+ mac_4in2b

.control
set wr_vecnames

tran 0.5n 2.5u uic

wrdata mac_transient.txt v(bl) v(phi_e) v(phi_r) v(en0b0)

* Measure bitline during eval phase of cycles 2 and 3
meas tran vbl_eval2 FIND v(bl) AT=780n
meas tran vbl_peak2 MAX v(bl) FROM=720n TO=820n
meas tran vbl_eval3 FIND v(bl) AT=1280n

* Cap top-plate voltages at end of sample (just before sample TGs open)
meas tran vt0b0 FIND v(xmac.top0b0) AT=195n
meas tran vt0b1 FIND v(xmac.top0b1) AT=195n
meas tran vt1b0 FIND v(xmac.top1b0) AT=195n
meas tran vt2b1 FIND v(xmac.top2b1) AT=195n
meas tran vt3b0 FIND v(xmac.top3b0) AT=195n

echo "========================================"
echo "MAC Transient Results (TT 27C)"
echo "========================================"
echo "RESULT: vbl_eval2 = $&vbl_eval2"
echo "RESULT: vbl_peak2 = $&vbl_peak2"
echo "RESULT: vbl_eval3 = $&vbl_eval3"
echo ""
echo "Expected Vbl = 292.5fC / 630fF = 0.464V"
echo "(All 8 caps connect during eval, disabled ones at 0V)"
echo ""
echo "Cap top-plate voltages at end of sample:"
echo "  top0b0 (in0=0.9V, w=1): $&vt0b0"
echo "  top0b1 (in0=0.9V, w=1): $&vt0b1"
echo "  top1b0 (in1=0.45, w=1): $&vt1b0"
echo "  top2b1 (in2=1.35, w=1): $&vt2b1"
echo "  top3b0 (in3=0.6V, w=0 disabled): $&vt3b0"

let err_pct = 100 * (vbl_eval3 - 0.464) / 0.464
echo ""
echo "RESULT: error_pct = $&err_pct"
echo "========================================"

quit
.endc

.end

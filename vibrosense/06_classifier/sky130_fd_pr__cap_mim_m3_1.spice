* SKY130 MIM Capacitor Model — sky130_fd_pr__cap_mim_m3_1
*
* Metal3-Metal4 MIM capacitor subcircuit for ngspice
* Based on SKY130 PDK xschem symbol parameters:
*   Area capacitance:  2.0 fF/um²
*   Fringe capacitance: 0.38 fF/um (perimeter)
*
* Ports: c0 (top plate, Metal4), c1 (bottom plate, Metal3)
* Parameters: W (width, um), L (length, um), MF (multiplier)
*
* Parasitic model:
*   - Bottom plate to substrate: ~0.1 fF/um² (M3 to substrate)
*   - Series resistance: rm3 ≈ 0.047 Ω/sq (Metal3 sheet R)
*   - Voltage coefficient: ~50 ppm/V (BSIM3-style vc1, vc2)
*
* Mismatch model (for MC analysis):
*   σ(ΔC/C) = Ac / sqrt(W × L)
*   Ac ≈ 0.45 %·um for SKY130 MIM
*   Applied via 'mc_cap_mismatch' parameter (0 = disabled, 1 = enabled)
*
* Reference: SkyWater SKY130 PDK, xschem symbol cap_mim_m3_1.sym

.param mc_cap_mismatch = 0

.subckt sky130_fd_pr__cap_mim_m3_1 c0 c1
+ params: W=5 L=5 MF=1

* Main capacitance: area + fringe
.param c_area = {W * L * 2.0e-15}
.param c_fringe = {(W + L) * 2 * 0.38e-15}
.param c_main = {MF * (c_area + c_fringe)}

* Bottom-plate parasitic (M3 to substrate via oxide)
* ~0.1 fF/um² (much less than main cap)
.param c_bp = {MF * W * L * 0.1e-15}

* Voltage coefficient: C(V) = C0 × (1 + vc1×V + vc2×V²)
* For MIM on SKY130: vc1 ≈ 40 ppm/V, vc2 ≈ -5 ppm/V²
* In ngspice, ideal caps don't support voltage coefficients,
* so we model the main cap as a fixed C (accurate to ~0.01% over 0-1.8V range)
Cmain c0 c1 {c_main}

* Bottom-plate parasitic cap to ground (substrate)
Cbp c1 0 {c_bp}

* Series resistance of bottom plate (Metal3)
* Rsh ≈ 0.047 Ω/sq, squares ≈ L/W for current flow direction
* This is negligible (<1Ω) for most sizes but included for completeness
* Rbp c1_int c1 {0.047 * L / W + 0.001}

.ends sky130_fd_pr__cap_mim_m3_1

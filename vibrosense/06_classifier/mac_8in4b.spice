* VibroSense Block 06: Full MAC Unit — 8 inputs × 4-bit weights
* Process: SKY130A | Supply: 1.8V
* Generated by gen_mac_8in4b.py
* Bottom-plate parasitic caps included (10% of MIM cap value)
*
* Cunit = 50 fF | Bits: 1×Cunit=50fF, 2×Cunit=100fF, 4×Cunit=200fF, 8×Cunit=400fF
* Max weight per input = 15 → 750 fF
* Total cap (all max): 6000 fF + parasitic

.subckt mac_8in4b
+ bl vss vdd in0 in1 in2 in3 in4
+ in5 in6 in7 phi_e phi_eb phi_r en0b0 en0b0b
+ en0b1 en0b1b en0b2 en0b2b en0b3 en0b3b en1b0 en1b0b
+ en1b1 en1b1b en1b2 en1b2b en1b3 en1b3b en2b0 en2b0b
+ en2b1 en2b1b en2b2 en2b2b en2b3 en2b3b en3b0 en3b0b
+ en3b1 en3b1b en3b2 en3b2b en3b3 en3b3b en4b0 en4b0b
+ en4b1 en4b1b en4b2 en4b2b en4b3 en4b3b en5b0 en5b0b
+ en5b1 en5b1b en5b2 en5b2b en5b3 en5b3b en6b0 en6b0b
+ en6b1 en6b1b en6b2 en6b2b en6b3 en6b3b en7b0 en7b0b
+ en7b1 en7b1b en7b2 en7b2b en7b3 en7b3b

.param cunit = 50f

* --- INPUT 0, BIT 0 (1×Cunit = 50fF) ---
XNt0b0 in0 en0b0 top0b0 vss sky130_fd_pr__nfet_01v8 W=0.84u L=0.15u
XPt0b0 in0 en0b0b top0b0 vdd sky130_fd_pr__pfet_01v8 W=1.68u L=0.15u
C0b0 top0b0 vss {1*cunit}
Cbp0b0 top0b0 vss 5.0f
XNe0b0 top0b0 phi_e bl vss sky130_fd_pr__nfet_01v8 W=0.84u L=0.15u
XPe0b0 top0b0 phi_eb bl vdd sky130_fd_pr__pfet_01v8 W=1.68u L=0.15u
XNr0b0 top0b0 phi_r vss vss sky130_fd_pr__nfet_01v8 W=0.42u L=0.15u

* --- INPUT 0, BIT 1 (2×Cunit = 100fF) ---
XNt0b1 in0 en0b1 top0b1 vss sky130_fd_pr__nfet_01v8 W=0.84u L=0.15u
XPt0b1 in0 en0b1b top0b1 vdd sky130_fd_pr__pfet_01v8 W=1.68u L=0.15u
C0b1 top0b1 vss {2*cunit}
Cbp0b1 top0b1 vss 10.0f
XNe0b1 top0b1 phi_e bl vss sky130_fd_pr__nfet_01v8 W=0.84u L=0.15u
XPe0b1 top0b1 phi_eb bl vdd sky130_fd_pr__pfet_01v8 W=1.68u L=0.15u
XNr0b1 top0b1 phi_r vss vss sky130_fd_pr__nfet_01v8 W=0.42u L=0.15u

* --- INPUT 0, BIT 2 (4×Cunit = 200fF) ---
XNt0b2 in0 en0b2 top0b2 vss sky130_fd_pr__nfet_01v8 W=0.84u L=0.15u
XPt0b2 in0 en0b2b top0b2 vdd sky130_fd_pr__pfet_01v8 W=1.68u L=0.15u
C0b2 top0b2 vss {4*cunit}
Cbp0b2 top0b2 vss 20.0f
XNe0b2 top0b2 phi_e bl vss sky130_fd_pr__nfet_01v8 W=0.84u L=0.15u
XPe0b2 top0b2 phi_eb bl vdd sky130_fd_pr__pfet_01v8 W=1.68u L=0.15u
XNr0b2 top0b2 phi_r vss vss sky130_fd_pr__nfet_01v8 W=0.42u L=0.15u

* --- INPUT 0, BIT 3 (8×Cunit = 400fF) ---
XNt0b3 in0 en0b3 top0b3 vss sky130_fd_pr__nfet_01v8 W=0.84u L=0.15u
XPt0b3 in0 en0b3b top0b3 vdd sky130_fd_pr__pfet_01v8 W=1.68u L=0.15u
C0b3 top0b3 vss {8*cunit}
Cbp0b3 top0b3 vss 40.0f
XNe0b3 top0b3 phi_e bl vss sky130_fd_pr__nfet_01v8 W=0.84u L=0.15u
XPe0b3 top0b3 phi_eb bl vdd sky130_fd_pr__pfet_01v8 W=1.68u L=0.15u
XNr0b3 top0b3 phi_r vss vss sky130_fd_pr__nfet_01v8 W=0.42u L=0.15u

* --- INPUT 1, BIT 0 (1×Cunit = 50fF) ---
XNt1b0 in1 en1b0 top1b0 vss sky130_fd_pr__nfet_01v8 W=0.84u L=0.15u
XPt1b0 in1 en1b0b top1b0 vdd sky130_fd_pr__pfet_01v8 W=1.68u L=0.15u
C1b0 top1b0 vss {1*cunit}
Cbp1b0 top1b0 vss 5.0f
XNe1b0 top1b0 phi_e bl vss sky130_fd_pr__nfet_01v8 W=0.84u L=0.15u
XPe1b0 top1b0 phi_eb bl vdd sky130_fd_pr__pfet_01v8 W=1.68u L=0.15u
XNr1b0 top1b0 phi_r vss vss sky130_fd_pr__nfet_01v8 W=0.42u L=0.15u

* --- INPUT 1, BIT 1 (2×Cunit = 100fF) ---
XNt1b1 in1 en1b1 top1b1 vss sky130_fd_pr__nfet_01v8 W=0.84u L=0.15u
XPt1b1 in1 en1b1b top1b1 vdd sky130_fd_pr__pfet_01v8 W=1.68u L=0.15u
C1b1 top1b1 vss {2*cunit}
Cbp1b1 top1b1 vss 10.0f
XNe1b1 top1b1 phi_e bl vss sky130_fd_pr__nfet_01v8 W=0.84u L=0.15u
XPe1b1 top1b1 phi_eb bl vdd sky130_fd_pr__pfet_01v8 W=1.68u L=0.15u
XNr1b1 top1b1 phi_r vss vss sky130_fd_pr__nfet_01v8 W=0.42u L=0.15u

* --- INPUT 1, BIT 2 (4×Cunit = 200fF) ---
XNt1b2 in1 en1b2 top1b2 vss sky130_fd_pr__nfet_01v8 W=0.84u L=0.15u
XPt1b2 in1 en1b2b top1b2 vdd sky130_fd_pr__pfet_01v8 W=1.68u L=0.15u
C1b2 top1b2 vss {4*cunit}
Cbp1b2 top1b2 vss 20.0f
XNe1b2 top1b2 phi_e bl vss sky130_fd_pr__nfet_01v8 W=0.84u L=0.15u
XPe1b2 top1b2 phi_eb bl vdd sky130_fd_pr__pfet_01v8 W=1.68u L=0.15u
XNr1b2 top1b2 phi_r vss vss sky130_fd_pr__nfet_01v8 W=0.42u L=0.15u

* --- INPUT 1, BIT 3 (8×Cunit = 400fF) ---
XNt1b3 in1 en1b3 top1b3 vss sky130_fd_pr__nfet_01v8 W=0.84u L=0.15u
XPt1b3 in1 en1b3b top1b3 vdd sky130_fd_pr__pfet_01v8 W=1.68u L=0.15u
C1b3 top1b3 vss {8*cunit}
Cbp1b3 top1b3 vss 40.0f
XNe1b3 top1b3 phi_e bl vss sky130_fd_pr__nfet_01v8 W=0.84u L=0.15u
XPe1b3 top1b3 phi_eb bl vdd sky130_fd_pr__pfet_01v8 W=1.68u L=0.15u
XNr1b3 top1b3 phi_r vss vss sky130_fd_pr__nfet_01v8 W=0.42u L=0.15u

* --- INPUT 2, BIT 0 (1×Cunit = 50fF) ---
XNt2b0 in2 en2b0 top2b0 vss sky130_fd_pr__nfet_01v8 W=0.84u L=0.15u
XPt2b0 in2 en2b0b top2b0 vdd sky130_fd_pr__pfet_01v8 W=1.68u L=0.15u
C2b0 top2b0 vss {1*cunit}
Cbp2b0 top2b0 vss 5.0f
XNe2b0 top2b0 phi_e bl vss sky130_fd_pr__nfet_01v8 W=0.84u L=0.15u
XPe2b0 top2b0 phi_eb bl vdd sky130_fd_pr__pfet_01v8 W=1.68u L=0.15u
XNr2b0 top2b0 phi_r vss vss sky130_fd_pr__nfet_01v8 W=0.42u L=0.15u

* --- INPUT 2, BIT 1 (2×Cunit = 100fF) ---
XNt2b1 in2 en2b1 top2b1 vss sky130_fd_pr__nfet_01v8 W=0.84u L=0.15u
XPt2b1 in2 en2b1b top2b1 vdd sky130_fd_pr__pfet_01v8 W=1.68u L=0.15u
C2b1 top2b1 vss {2*cunit}
Cbp2b1 top2b1 vss 10.0f
XNe2b1 top2b1 phi_e bl vss sky130_fd_pr__nfet_01v8 W=0.84u L=0.15u
XPe2b1 top2b1 phi_eb bl vdd sky130_fd_pr__pfet_01v8 W=1.68u L=0.15u
XNr2b1 top2b1 phi_r vss vss sky130_fd_pr__nfet_01v8 W=0.42u L=0.15u

* --- INPUT 2, BIT 2 (4×Cunit = 200fF) ---
XNt2b2 in2 en2b2 top2b2 vss sky130_fd_pr__nfet_01v8 W=0.84u L=0.15u
XPt2b2 in2 en2b2b top2b2 vdd sky130_fd_pr__pfet_01v8 W=1.68u L=0.15u
C2b2 top2b2 vss {4*cunit}
Cbp2b2 top2b2 vss 20.0f
XNe2b2 top2b2 phi_e bl vss sky130_fd_pr__nfet_01v8 W=0.84u L=0.15u
XPe2b2 top2b2 phi_eb bl vdd sky130_fd_pr__pfet_01v8 W=1.68u L=0.15u
XNr2b2 top2b2 phi_r vss vss sky130_fd_pr__nfet_01v8 W=0.42u L=0.15u

* --- INPUT 2, BIT 3 (8×Cunit = 400fF) ---
XNt2b3 in2 en2b3 top2b3 vss sky130_fd_pr__nfet_01v8 W=0.84u L=0.15u
XPt2b3 in2 en2b3b top2b3 vdd sky130_fd_pr__pfet_01v8 W=1.68u L=0.15u
C2b3 top2b3 vss {8*cunit}
Cbp2b3 top2b3 vss 40.0f
XNe2b3 top2b3 phi_e bl vss sky130_fd_pr__nfet_01v8 W=0.84u L=0.15u
XPe2b3 top2b3 phi_eb bl vdd sky130_fd_pr__pfet_01v8 W=1.68u L=0.15u
XNr2b3 top2b3 phi_r vss vss sky130_fd_pr__nfet_01v8 W=0.42u L=0.15u

* --- INPUT 3, BIT 0 (1×Cunit = 50fF) ---
XNt3b0 in3 en3b0 top3b0 vss sky130_fd_pr__nfet_01v8 W=0.84u L=0.15u
XPt3b0 in3 en3b0b top3b0 vdd sky130_fd_pr__pfet_01v8 W=1.68u L=0.15u
C3b0 top3b0 vss {1*cunit}
Cbp3b0 top3b0 vss 5.0f
XNe3b0 top3b0 phi_e bl vss sky130_fd_pr__nfet_01v8 W=0.84u L=0.15u
XPe3b0 top3b0 phi_eb bl vdd sky130_fd_pr__pfet_01v8 W=1.68u L=0.15u
XNr3b0 top3b0 phi_r vss vss sky130_fd_pr__nfet_01v8 W=0.42u L=0.15u

* --- INPUT 3, BIT 1 (2×Cunit = 100fF) ---
XNt3b1 in3 en3b1 top3b1 vss sky130_fd_pr__nfet_01v8 W=0.84u L=0.15u
XPt3b1 in3 en3b1b top3b1 vdd sky130_fd_pr__pfet_01v8 W=1.68u L=0.15u
C3b1 top3b1 vss {2*cunit}
Cbp3b1 top3b1 vss 10.0f
XNe3b1 top3b1 phi_e bl vss sky130_fd_pr__nfet_01v8 W=0.84u L=0.15u
XPe3b1 top3b1 phi_eb bl vdd sky130_fd_pr__pfet_01v8 W=1.68u L=0.15u
XNr3b1 top3b1 phi_r vss vss sky130_fd_pr__nfet_01v8 W=0.42u L=0.15u

* --- INPUT 3, BIT 2 (4×Cunit = 200fF) ---
XNt3b2 in3 en3b2 top3b2 vss sky130_fd_pr__nfet_01v8 W=0.84u L=0.15u
XPt3b2 in3 en3b2b top3b2 vdd sky130_fd_pr__pfet_01v8 W=1.68u L=0.15u
C3b2 top3b2 vss {4*cunit}
Cbp3b2 top3b2 vss 20.0f
XNe3b2 top3b2 phi_e bl vss sky130_fd_pr__nfet_01v8 W=0.84u L=0.15u
XPe3b2 top3b2 phi_eb bl vdd sky130_fd_pr__pfet_01v8 W=1.68u L=0.15u
XNr3b2 top3b2 phi_r vss vss sky130_fd_pr__nfet_01v8 W=0.42u L=0.15u

* --- INPUT 3, BIT 3 (8×Cunit = 400fF) ---
XNt3b3 in3 en3b3 top3b3 vss sky130_fd_pr__nfet_01v8 W=0.84u L=0.15u
XPt3b3 in3 en3b3b top3b3 vdd sky130_fd_pr__pfet_01v8 W=1.68u L=0.15u
C3b3 top3b3 vss {8*cunit}
Cbp3b3 top3b3 vss 40.0f
XNe3b3 top3b3 phi_e bl vss sky130_fd_pr__nfet_01v8 W=0.84u L=0.15u
XPe3b3 top3b3 phi_eb bl vdd sky130_fd_pr__pfet_01v8 W=1.68u L=0.15u
XNr3b3 top3b3 phi_r vss vss sky130_fd_pr__nfet_01v8 W=0.42u L=0.15u

* --- INPUT 4, BIT 0 (1×Cunit = 50fF) ---
XNt4b0 in4 en4b0 top4b0 vss sky130_fd_pr__nfet_01v8 W=0.84u L=0.15u
XPt4b0 in4 en4b0b top4b0 vdd sky130_fd_pr__pfet_01v8 W=1.68u L=0.15u
C4b0 top4b0 vss {1*cunit}
Cbp4b0 top4b0 vss 5.0f
XNe4b0 top4b0 phi_e bl vss sky130_fd_pr__nfet_01v8 W=0.84u L=0.15u
XPe4b0 top4b0 phi_eb bl vdd sky130_fd_pr__pfet_01v8 W=1.68u L=0.15u
XNr4b0 top4b0 phi_r vss vss sky130_fd_pr__nfet_01v8 W=0.42u L=0.15u

* --- INPUT 4, BIT 1 (2×Cunit = 100fF) ---
XNt4b1 in4 en4b1 top4b1 vss sky130_fd_pr__nfet_01v8 W=0.84u L=0.15u
XPt4b1 in4 en4b1b top4b1 vdd sky130_fd_pr__pfet_01v8 W=1.68u L=0.15u
C4b1 top4b1 vss {2*cunit}
Cbp4b1 top4b1 vss 10.0f
XNe4b1 top4b1 phi_e bl vss sky130_fd_pr__nfet_01v8 W=0.84u L=0.15u
XPe4b1 top4b1 phi_eb bl vdd sky130_fd_pr__pfet_01v8 W=1.68u L=0.15u
XNr4b1 top4b1 phi_r vss vss sky130_fd_pr__nfet_01v8 W=0.42u L=0.15u

* --- INPUT 4, BIT 2 (4×Cunit = 200fF) ---
XNt4b2 in4 en4b2 top4b2 vss sky130_fd_pr__nfet_01v8 W=0.84u L=0.15u
XPt4b2 in4 en4b2b top4b2 vdd sky130_fd_pr__pfet_01v8 W=1.68u L=0.15u
C4b2 top4b2 vss {4*cunit}
Cbp4b2 top4b2 vss 20.0f
XNe4b2 top4b2 phi_e bl vss sky130_fd_pr__nfet_01v8 W=0.84u L=0.15u
XPe4b2 top4b2 phi_eb bl vdd sky130_fd_pr__pfet_01v8 W=1.68u L=0.15u
XNr4b2 top4b2 phi_r vss vss sky130_fd_pr__nfet_01v8 W=0.42u L=0.15u

* --- INPUT 4, BIT 3 (8×Cunit = 400fF) ---
XNt4b3 in4 en4b3 top4b3 vss sky130_fd_pr__nfet_01v8 W=0.84u L=0.15u
XPt4b3 in4 en4b3b top4b3 vdd sky130_fd_pr__pfet_01v8 W=1.68u L=0.15u
C4b3 top4b3 vss {8*cunit}
Cbp4b3 top4b3 vss 40.0f
XNe4b3 top4b3 phi_e bl vss sky130_fd_pr__nfet_01v8 W=0.84u L=0.15u
XPe4b3 top4b3 phi_eb bl vdd sky130_fd_pr__pfet_01v8 W=1.68u L=0.15u
XNr4b3 top4b3 phi_r vss vss sky130_fd_pr__nfet_01v8 W=0.42u L=0.15u

* --- INPUT 5, BIT 0 (1×Cunit = 50fF) ---
XNt5b0 in5 en5b0 top5b0 vss sky130_fd_pr__nfet_01v8 W=0.84u L=0.15u
XPt5b0 in5 en5b0b top5b0 vdd sky130_fd_pr__pfet_01v8 W=1.68u L=0.15u
C5b0 top5b0 vss {1*cunit}
Cbp5b0 top5b0 vss 5.0f
XNe5b0 top5b0 phi_e bl vss sky130_fd_pr__nfet_01v8 W=0.84u L=0.15u
XPe5b0 top5b0 phi_eb bl vdd sky130_fd_pr__pfet_01v8 W=1.68u L=0.15u
XNr5b0 top5b0 phi_r vss vss sky130_fd_pr__nfet_01v8 W=0.42u L=0.15u

* --- INPUT 5, BIT 1 (2×Cunit = 100fF) ---
XNt5b1 in5 en5b1 top5b1 vss sky130_fd_pr__nfet_01v8 W=0.84u L=0.15u
XPt5b1 in5 en5b1b top5b1 vdd sky130_fd_pr__pfet_01v8 W=1.68u L=0.15u
C5b1 top5b1 vss {2*cunit}
Cbp5b1 top5b1 vss 10.0f
XNe5b1 top5b1 phi_e bl vss sky130_fd_pr__nfet_01v8 W=0.84u L=0.15u
XPe5b1 top5b1 phi_eb bl vdd sky130_fd_pr__pfet_01v8 W=1.68u L=0.15u
XNr5b1 top5b1 phi_r vss vss sky130_fd_pr__nfet_01v8 W=0.42u L=0.15u

* --- INPUT 5, BIT 2 (4×Cunit = 200fF) ---
XNt5b2 in5 en5b2 top5b2 vss sky130_fd_pr__nfet_01v8 W=0.84u L=0.15u
XPt5b2 in5 en5b2b top5b2 vdd sky130_fd_pr__pfet_01v8 W=1.68u L=0.15u
C5b2 top5b2 vss {4*cunit}
Cbp5b2 top5b2 vss 20.0f
XNe5b2 top5b2 phi_e bl vss sky130_fd_pr__nfet_01v8 W=0.84u L=0.15u
XPe5b2 top5b2 phi_eb bl vdd sky130_fd_pr__pfet_01v8 W=1.68u L=0.15u
XNr5b2 top5b2 phi_r vss vss sky130_fd_pr__nfet_01v8 W=0.42u L=0.15u

* --- INPUT 5, BIT 3 (8×Cunit = 400fF) ---
XNt5b3 in5 en5b3 top5b3 vss sky130_fd_pr__nfet_01v8 W=0.84u L=0.15u
XPt5b3 in5 en5b3b top5b3 vdd sky130_fd_pr__pfet_01v8 W=1.68u L=0.15u
C5b3 top5b3 vss {8*cunit}
Cbp5b3 top5b3 vss 40.0f
XNe5b3 top5b3 phi_e bl vss sky130_fd_pr__nfet_01v8 W=0.84u L=0.15u
XPe5b3 top5b3 phi_eb bl vdd sky130_fd_pr__pfet_01v8 W=1.68u L=0.15u
XNr5b3 top5b3 phi_r vss vss sky130_fd_pr__nfet_01v8 W=0.42u L=0.15u

* --- INPUT 6, BIT 0 (1×Cunit = 50fF) ---
XNt6b0 in6 en6b0 top6b0 vss sky130_fd_pr__nfet_01v8 W=0.84u L=0.15u
XPt6b0 in6 en6b0b top6b0 vdd sky130_fd_pr__pfet_01v8 W=1.68u L=0.15u
C6b0 top6b0 vss {1*cunit}
Cbp6b0 top6b0 vss 5.0f
XNe6b0 top6b0 phi_e bl vss sky130_fd_pr__nfet_01v8 W=0.84u L=0.15u
XPe6b0 top6b0 phi_eb bl vdd sky130_fd_pr__pfet_01v8 W=1.68u L=0.15u
XNr6b0 top6b0 phi_r vss vss sky130_fd_pr__nfet_01v8 W=0.42u L=0.15u

* --- INPUT 6, BIT 1 (2×Cunit = 100fF) ---
XNt6b1 in6 en6b1 top6b1 vss sky130_fd_pr__nfet_01v8 W=0.84u L=0.15u
XPt6b1 in6 en6b1b top6b1 vdd sky130_fd_pr__pfet_01v8 W=1.68u L=0.15u
C6b1 top6b1 vss {2*cunit}
Cbp6b1 top6b1 vss 10.0f
XNe6b1 top6b1 phi_e bl vss sky130_fd_pr__nfet_01v8 W=0.84u L=0.15u
XPe6b1 top6b1 phi_eb bl vdd sky130_fd_pr__pfet_01v8 W=1.68u L=0.15u
XNr6b1 top6b1 phi_r vss vss sky130_fd_pr__nfet_01v8 W=0.42u L=0.15u

* --- INPUT 6, BIT 2 (4×Cunit = 200fF) ---
XNt6b2 in6 en6b2 top6b2 vss sky130_fd_pr__nfet_01v8 W=0.84u L=0.15u
XPt6b2 in6 en6b2b top6b2 vdd sky130_fd_pr__pfet_01v8 W=1.68u L=0.15u
C6b2 top6b2 vss {4*cunit}
Cbp6b2 top6b2 vss 20.0f
XNe6b2 top6b2 phi_e bl vss sky130_fd_pr__nfet_01v8 W=0.84u L=0.15u
XPe6b2 top6b2 phi_eb bl vdd sky130_fd_pr__pfet_01v8 W=1.68u L=0.15u
XNr6b2 top6b2 phi_r vss vss sky130_fd_pr__nfet_01v8 W=0.42u L=0.15u

* --- INPUT 6, BIT 3 (8×Cunit = 400fF) ---
XNt6b3 in6 en6b3 top6b3 vss sky130_fd_pr__nfet_01v8 W=0.84u L=0.15u
XPt6b3 in6 en6b3b top6b3 vdd sky130_fd_pr__pfet_01v8 W=1.68u L=0.15u
C6b3 top6b3 vss {8*cunit}
Cbp6b3 top6b3 vss 40.0f
XNe6b3 top6b3 phi_e bl vss sky130_fd_pr__nfet_01v8 W=0.84u L=0.15u
XPe6b3 top6b3 phi_eb bl vdd sky130_fd_pr__pfet_01v8 W=1.68u L=0.15u
XNr6b3 top6b3 phi_r vss vss sky130_fd_pr__nfet_01v8 W=0.42u L=0.15u

* --- INPUT 7, BIT 0 (1×Cunit = 50fF) ---
XNt7b0 in7 en7b0 top7b0 vss sky130_fd_pr__nfet_01v8 W=0.84u L=0.15u
XPt7b0 in7 en7b0b top7b0 vdd sky130_fd_pr__pfet_01v8 W=1.68u L=0.15u
C7b0 top7b0 vss {1*cunit}
Cbp7b0 top7b0 vss 5.0f
XNe7b0 top7b0 phi_e bl vss sky130_fd_pr__nfet_01v8 W=0.84u L=0.15u
XPe7b0 top7b0 phi_eb bl vdd sky130_fd_pr__pfet_01v8 W=1.68u L=0.15u
XNr7b0 top7b0 phi_r vss vss sky130_fd_pr__nfet_01v8 W=0.42u L=0.15u

* --- INPUT 7, BIT 1 (2×Cunit = 100fF) ---
XNt7b1 in7 en7b1 top7b1 vss sky130_fd_pr__nfet_01v8 W=0.84u L=0.15u
XPt7b1 in7 en7b1b top7b1 vdd sky130_fd_pr__pfet_01v8 W=1.68u L=0.15u
C7b1 top7b1 vss {2*cunit}
Cbp7b1 top7b1 vss 10.0f
XNe7b1 top7b1 phi_e bl vss sky130_fd_pr__nfet_01v8 W=0.84u L=0.15u
XPe7b1 top7b1 phi_eb bl vdd sky130_fd_pr__pfet_01v8 W=1.68u L=0.15u
XNr7b1 top7b1 phi_r vss vss sky130_fd_pr__nfet_01v8 W=0.42u L=0.15u

* --- INPUT 7, BIT 2 (4×Cunit = 200fF) ---
XNt7b2 in7 en7b2 top7b2 vss sky130_fd_pr__nfet_01v8 W=0.84u L=0.15u
XPt7b2 in7 en7b2b top7b2 vdd sky130_fd_pr__pfet_01v8 W=1.68u L=0.15u
C7b2 top7b2 vss {4*cunit}
Cbp7b2 top7b2 vss 20.0f
XNe7b2 top7b2 phi_e bl vss sky130_fd_pr__nfet_01v8 W=0.84u L=0.15u
XPe7b2 top7b2 phi_eb bl vdd sky130_fd_pr__pfet_01v8 W=1.68u L=0.15u
XNr7b2 top7b2 phi_r vss vss sky130_fd_pr__nfet_01v8 W=0.42u L=0.15u

* --- INPUT 7, BIT 3 (8×Cunit = 400fF) ---
XNt7b3 in7 en7b3 top7b3 vss sky130_fd_pr__nfet_01v8 W=0.84u L=0.15u
XPt7b3 in7 en7b3b top7b3 vdd sky130_fd_pr__pfet_01v8 W=1.68u L=0.15u
C7b3 top7b3 vss {8*cunit}
Cbp7b3 top7b3 vss 40.0f
XNe7b3 top7b3 phi_e bl vss sky130_fd_pr__nfet_01v8 W=0.84u L=0.15u
XPe7b3 top7b3 phi_eb bl vdd sky130_fd_pr__pfet_01v8 W=1.68u L=0.15u
XNr7b3 top7b3 phi_r vss vss sky130_fd_pr__nfet_01v8 W=0.42u L=0.15u

* --- Bitline reset + routing parasitic ---
XNblrst bl phi_r vss vss sky130_fd_pr__nfet_01v8 W=0.84u L=0.15u
Cpar bl vss 80f

.ends mac_8in4b

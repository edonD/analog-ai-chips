* VibroSense Block 06: Full MAC Unit — 8 inputs × 4-bit weights
* Process: SKY130A | Supply: 1.8V
* Capacitors: sky130_fd_pr__cap_mim_m3_1 (real PDK MIM cap model)
* Generated by gen_mac_8in4b.py
*
* Bit 0: W=4.63um L=4.63um → Cmain=50.0fF Cbp=2.15fF
* Bit 1: W=6.7um L=6.7um → Cmain=100.0fF Cbp=4.49fF
* Bit 2: W=9.63um L=9.63um → Cmain=200.0fF Cbp=9.27fF
* Bit 3: W=13.77um L=13.77um → Cmain=400.0fF Cbp=18.95fF

.subckt mac_8in4b
+ bl vss vdd in0 in1 in2 in3 in4
+ in5 in6 in7 phi_e phi_eb phi_r en0b0 en0b0b
+ en0b1 en0b1b en0b2 en0b2b en0b3 en0b3b en1b0 en1b0b
+ en1b1 en1b1b en1b2 en1b2b en1b3 en1b3b en2b0 en2b0b
+ en2b1 en2b1b en2b2 en2b2b en2b3 en2b3b en3b0 en3b0b
+ en3b1 en3b1b en3b2 en3b2b en3b3 en3b3b en4b0 en4b0b
+ en4b1 en4b1b en4b2 en4b2b en4b3 en4b3b en5b0 en5b0b
+ en5b1 en5b1b en5b2 en5b2b en5b3 en5b3b en6b0 en6b0b
+ en6b1 en6b1b en6b2 en6b2b en6b3 en6b3b en7b0 en7b0b
+ en7b1 en7b1b en7b2 en7b2b en7b3 en7b3b

* --- INPUT 0, BIT 0 (1×Cunit ≈ 50.0fF MIM, W=4.63 L=4.63) ---
XNt0b0 in0 en0b0 top0b0 vss sky130_fd_pr__nfet_01v8 W=0.84u L=0.15u
XPt0b0 in0 en0b0b top0b0 vdd sky130_fd_pr__pfet_01v8 W=1.68u L=0.15u
XC0b0 top0b0 vss sky130_fd_pr__cap_mim_m3_1 W=4.63 L=4.63 MF=1
XNe0b0 top0b0 phi_e bl vss sky130_fd_pr__nfet_01v8 W=0.84u L=0.15u
XPe0b0 top0b0 phi_eb bl vdd sky130_fd_pr__pfet_01v8 W=1.68u L=0.15u
XNr0b0 top0b0 phi_r vss vss sky130_fd_pr__nfet_01v8 W=0.42u L=0.15u

* --- INPUT 0, BIT 1 (2×Cunit ≈ 100.0fF MIM, W=6.7 L=6.7) ---
XNt0b1 in0 en0b1 top0b1 vss sky130_fd_pr__nfet_01v8 W=0.84u L=0.15u
XPt0b1 in0 en0b1b top0b1 vdd sky130_fd_pr__pfet_01v8 W=1.68u L=0.15u
XC0b1 top0b1 vss sky130_fd_pr__cap_mim_m3_1 W=6.7 L=6.7 MF=1
XNe0b1 top0b1 phi_e bl vss sky130_fd_pr__nfet_01v8 W=0.84u L=0.15u
XPe0b1 top0b1 phi_eb bl vdd sky130_fd_pr__pfet_01v8 W=1.68u L=0.15u
XNr0b1 top0b1 phi_r vss vss sky130_fd_pr__nfet_01v8 W=0.42u L=0.15u

* --- INPUT 0, BIT 2 (4×Cunit ≈ 200.0fF MIM, W=9.63 L=9.63) ---
XNt0b2 in0 en0b2 top0b2 vss sky130_fd_pr__nfet_01v8 W=0.84u L=0.15u
XPt0b2 in0 en0b2b top0b2 vdd sky130_fd_pr__pfet_01v8 W=1.68u L=0.15u
XC0b2 top0b2 vss sky130_fd_pr__cap_mim_m3_1 W=9.63 L=9.63 MF=1
XNe0b2 top0b2 phi_e bl vss sky130_fd_pr__nfet_01v8 W=0.84u L=0.15u
XPe0b2 top0b2 phi_eb bl vdd sky130_fd_pr__pfet_01v8 W=1.68u L=0.15u
XNr0b2 top0b2 phi_r vss vss sky130_fd_pr__nfet_01v8 W=0.42u L=0.15u

* --- INPUT 0, BIT 3 (8×Cunit ≈ 400.0fF MIM, W=13.77 L=13.77) ---
XNt0b3 in0 en0b3 top0b3 vss sky130_fd_pr__nfet_01v8 W=0.84u L=0.15u
XPt0b3 in0 en0b3b top0b3 vdd sky130_fd_pr__pfet_01v8 W=1.68u L=0.15u
XC0b3 top0b3 vss sky130_fd_pr__cap_mim_m3_1 W=13.77 L=13.77 MF=1
XNe0b3 top0b3 phi_e bl vss sky130_fd_pr__nfet_01v8 W=0.84u L=0.15u
XPe0b3 top0b3 phi_eb bl vdd sky130_fd_pr__pfet_01v8 W=1.68u L=0.15u
XNr0b3 top0b3 phi_r vss vss sky130_fd_pr__nfet_01v8 W=0.42u L=0.15u

* --- INPUT 1, BIT 0 (1×Cunit ≈ 50.0fF MIM, W=4.63 L=4.63) ---
XNt1b0 in1 en1b0 top1b0 vss sky130_fd_pr__nfet_01v8 W=0.84u L=0.15u
XPt1b0 in1 en1b0b top1b0 vdd sky130_fd_pr__pfet_01v8 W=1.68u L=0.15u
XC1b0 top1b0 vss sky130_fd_pr__cap_mim_m3_1 W=4.63 L=4.63 MF=1
XNe1b0 top1b0 phi_e bl vss sky130_fd_pr__nfet_01v8 W=0.84u L=0.15u
XPe1b0 top1b0 phi_eb bl vdd sky130_fd_pr__pfet_01v8 W=1.68u L=0.15u
XNr1b0 top1b0 phi_r vss vss sky130_fd_pr__nfet_01v8 W=0.42u L=0.15u

* --- INPUT 1, BIT 1 (2×Cunit ≈ 100.0fF MIM, W=6.7 L=6.7) ---
XNt1b1 in1 en1b1 top1b1 vss sky130_fd_pr__nfet_01v8 W=0.84u L=0.15u
XPt1b1 in1 en1b1b top1b1 vdd sky130_fd_pr__pfet_01v8 W=1.68u L=0.15u
XC1b1 top1b1 vss sky130_fd_pr__cap_mim_m3_1 W=6.7 L=6.7 MF=1
XNe1b1 top1b1 phi_e bl vss sky130_fd_pr__nfet_01v8 W=0.84u L=0.15u
XPe1b1 top1b1 phi_eb bl vdd sky130_fd_pr__pfet_01v8 W=1.68u L=0.15u
XNr1b1 top1b1 phi_r vss vss sky130_fd_pr__nfet_01v8 W=0.42u L=0.15u

* --- INPUT 1, BIT 2 (4×Cunit ≈ 200.0fF MIM, W=9.63 L=9.63) ---
XNt1b2 in1 en1b2 top1b2 vss sky130_fd_pr__nfet_01v8 W=0.84u L=0.15u
XPt1b2 in1 en1b2b top1b2 vdd sky130_fd_pr__pfet_01v8 W=1.68u L=0.15u
XC1b2 top1b2 vss sky130_fd_pr__cap_mim_m3_1 W=9.63 L=9.63 MF=1
XNe1b2 top1b2 phi_e bl vss sky130_fd_pr__nfet_01v8 W=0.84u L=0.15u
XPe1b2 top1b2 phi_eb bl vdd sky130_fd_pr__pfet_01v8 W=1.68u L=0.15u
XNr1b2 top1b2 phi_r vss vss sky130_fd_pr__nfet_01v8 W=0.42u L=0.15u

* --- INPUT 1, BIT 3 (8×Cunit ≈ 400.0fF MIM, W=13.77 L=13.77) ---
XNt1b3 in1 en1b3 top1b3 vss sky130_fd_pr__nfet_01v8 W=0.84u L=0.15u
XPt1b3 in1 en1b3b top1b3 vdd sky130_fd_pr__pfet_01v8 W=1.68u L=0.15u
XC1b3 top1b3 vss sky130_fd_pr__cap_mim_m3_1 W=13.77 L=13.77 MF=1
XNe1b3 top1b3 phi_e bl vss sky130_fd_pr__nfet_01v8 W=0.84u L=0.15u
XPe1b3 top1b3 phi_eb bl vdd sky130_fd_pr__pfet_01v8 W=1.68u L=0.15u
XNr1b3 top1b3 phi_r vss vss sky130_fd_pr__nfet_01v8 W=0.42u L=0.15u

* --- INPUT 2, BIT 0 (1×Cunit ≈ 50.0fF MIM, W=4.63 L=4.63) ---
XNt2b0 in2 en2b0 top2b0 vss sky130_fd_pr__nfet_01v8 W=0.84u L=0.15u
XPt2b0 in2 en2b0b top2b0 vdd sky130_fd_pr__pfet_01v8 W=1.68u L=0.15u
XC2b0 top2b0 vss sky130_fd_pr__cap_mim_m3_1 W=4.63 L=4.63 MF=1
XNe2b0 top2b0 phi_e bl vss sky130_fd_pr__nfet_01v8 W=0.84u L=0.15u
XPe2b0 top2b0 phi_eb bl vdd sky130_fd_pr__pfet_01v8 W=1.68u L=0.15u
XNr2b0 top2b0 phi_r vss vss sky130_fd_pr__nfet_01v8 W=0.42u L=0.15u

* --- INPUT 2, BIT 1 (2×Cunit ≈ 100.0fF MIM, W=6.7 L=6.7) ---
XNt2b1 in2 en2b1 top2b1 vss sky130_fd_pr__nfet_01v8 W=0.84u L=0.15u
XPt2b1 in2 en2b1b top2b1 vdd sky130_fd_pr__pfet_01v8 W=1.68u L=0.15u
XC2b1 top2b1 vss sky130_fd_pr__cap_mim_m3_1 W=6.7 L=6.7 MF=1
XNe2b1 top2b1 phi_e bl vss sky130_fd_pr__nfet_01v8 W=0.84u L=0.15u
XPe2b1 top2b1 phi_eb bl vdd sky130_fd_pr__pfet_01v8 W=1.68u L=0.15u
XNr2b1 top2b1 phi_r vss vss sky130_fd_pr__nfet_01v8 W=0.42u L=0.15u

* --- INPUT 2, BIT 2 (4×Cunit ≈ 200.0fF MIM, W=9.63 L=9.63) ---
XNt2b2 in2 en2b2 top2b2 vss sky130_fd_pr__nfet_01v8 W=0.84u L=0.15u
XPt2b2 in2 en2b2b top2b2 vdd sky130_fd_pr__pfet_01v8 W=1.68u L=0.15u
XC2b2 top2b2 vss sky130_fd_pr__cap_mim_m3_1 W=9.63 L=9.63 MF=1
XNe2b2 top2b2 phi_e bl vss sky130_fd_pr__nfet_01v8 W=0.84u L=0.15u
XPe2b2 top2b2 phi_eb bl vdd sky130_fd_pr__pfet_01v8 W=1.68u L=0.15u
XNr2b2 top2b2 phi_r vss vss sky130_fd_pr__nfet_01v8 W=0.42u L=0.15u

* --- INPUT 2, BIT 3 (8×Cunit ≈ 400.0fF MIM, W=13.77 L=13.77) ---
XNt2b3 in2 en2b3 top2b3 vss sky130_fd_pr__nfet_01v8 W=0.84u L=0.15u
XPt2b3 in2 en2b3b top2b3 vdd sky130_fd_pr__pfet_01v8 W=1.68u L=0.15u
XC2b3 top2b3 vss sky130_fd_pr__cap_mim_m3_1 W=13.77 L=13.77 MF=1
XNe2b3 top2b3 phi_e bl vss sky130_fd_pr__nfet_01v8 W=0.84u L=0.15u
XPe2b3 top2b3 phi_eb bl vdd sky130_fd_pr__pfet_01v8 W=1.68u L=0.15u
XNr2b3 top2b3 phi_r vss vss sky130_fd_pr__nfet_01v8 W=0.42u L=0.15u

* --- INPUT 3, BIT 0 (1×Cunit ≈ 50.0fF MIM, W=4.63 L=4.63) ---
XNt3b0 in3 en3b0 top3b0 vss sky130_fd_pr__nfet_01v8 W=0.84u L=0.15u
XPt3b0 in3 en3b0b top3b0 vdd sky130_fd_pr__pfet_01v8 W=1.68u L=0.15u
XC3b0 top3b0 vss sky130_fd_pr__cap_mim_m3_1 W=4.63 L=4.63 MF=1
XNe3b0 top3b0 phi_e bl vss sky130_fd_pr__nfet_01v8 W=0.84u L=0.15u
XPe3b0 top3b0 phi_eb bl vdd sky130_fd_pr__pfet_01v8 W=1.68u L=0.15u
XNr3b0 top3b0 phi_r vss vss sky130_fd_pr__nfet_01v8 W=0.42u L=0.15u

* --- INPUT 3, BIT 1 (2×Cunit ≈ 100.0fF MIM, W=6.7 L=6.7) ---
XNt3b1 in3 en3b1 top3b1 vss sky130_fd_pr__nfet_01v8 W=0.84u L=0.15u
XPt3b1 in3 en3b1b top3b1 vdd sky130_fd_pr__pfet_01v8 W=1.68u L=0.15u
XC3b1 top3b1 vss sky130_fd_pr__cap_mim_m3_1 W=6.7 L=6.7 MF=1
XNe3b1 top3b1 phi_e bl vss sky130_fd_pr__nfet_01v8 W=0.84u L=0.15u
XPe3b1 top3b1 phi_eb bl vdd sky130_fd_pr__pfet_01v8 W=1.68u L=0.15u
XNr3b1 top3b1 phi_r vss vss sky130_fd_pr__nfet_01v8 W=0.42u L=0.15u

* --- INPUT 3, BIT 2 (4×Cunit ≈ 200.0fF MIM, W=9.63 L=9.63) ---
XNt3b2 in3 en3b2 top3b2 vss sky130_fd_pr__nfet_01v8 W=0.84u L=0.15u
XPt3b2 in3 en3b2b top3b2 vdd sky130_fd_pr__pfet_01v8 W=1.68u L=0.15u
XC3b2 top3b2 vss sky130_fd_pr__cap_mim_m3_1 W=9.63 L=9.63 MF=1
XNe3b2 top3b2 phi_e bl vss sky130_fd_pr__nfet_01v8 W=0.84u L=0.15u
XPe3b2 top3b2 phi_eb bl vdd sky130_fd_pr__pfet_01v8 W=1.68u L=0.15u
XNr3b2 top3b2 phi_r vss vss sky130_fd_pr__nfet_01v8 W=0.42u L=0.15u

* --- INPUT 3, BIT 3 (8×Cunit ≈ 400.0fF MIM, W=13.77 L=13.77) ---
XNt3b3 in3 en3b3 top3b3 vss sky130_fd_pr__nfet_01v8 W=0.84u L=0.15u
XPt3b3 in3 en3b3b top3b3 vdd sky130_fd_pr__pfet_01v8 W=1.68u L=0.15u
XC3b3 top3b3 vss sky130_fd_pr__cap_mim_m3_1 W=13.77 L=13.77 MF=1
XNe3b3 top3b3 phi_e bl vss sky130_fd_pr__nfet_01v8 W=0.84u L=0.15u
XPe3b3 top3b3 phi_eb bl vdd sky130_fd_pr__pfet_01v8 W=1.68u L=0.15u
XNr3b3 top3b3 phi_r vss vss sky130_fd_pr__nfet_01v8 W=0.42u L=0.15u

* --- INPUT 4, BIT 0 (1×Cunit ≈ 50.0fF MIM, W=4.63 L=4.63) ---
XNt4b0 in4 en4b0 top4b0 vss sky130_fd_pr__nfet_01v8 W=0.84u L=0.15u
XPt4b0 in4 en4b0b top4b0 vdd sky130_fd_pr__pfet_01v8 W=1.68u L=0.15u
XC4b0 top4b0 vss sky130_fd_pr__cap_mim_m3_1 W=4.63 L=4.63 MF=1
XNe4b0 top4b0 phi_e bl vss sky130_fd_pr__nfet_01v8 W=0.84u L=0.15u
XPe4b0 top4b0 phi_eb bl vdd sky130_fd_pr__pfet_01v8 W=1.68u L=0.15u
XNr4b0 top4b0 phi_r vss vss sky130_fd_pr__nfet_01v8 W=0.42u L=0.15u

* --- INPUT 4, BIT 1 (2×Cunit ≈ 100.0fF MIM, W=6.7 L=6.7) ---
XNt4b1 in4 en4b1 top4b1 vss sky130_fd_pr__nfet_01v8 W=0.84u L=0.15u
XPt4b1 in4 en4b1b top4b1 vdd sky130_fd_pr__pfet_01v8 W=1.68u L=0.15u
XC4b1 top4b1 vss sky130_fd_pr__cap_mim_m3_1 W=6.7 L=6.7 MF=1
XNe4b1 top4b1 phi_e bl vss sky130_fd_pr__nfet_01v8 W=0.84u L=0.15u
XPe4b1 top4b1 phi_eb bl vdd sky130_fd_pr__pfet_01v8 W=1.68u L=0.15u
XNr4b1 top4b1 phi_r vss vss sky130_fd_pr__nfet_01v8 W=0.42u L=0.15u

* --- INPUT 4, BIT 2 (4×Cunit ≈ 200.0fF MIM, W=9.63 L=9.63) ---
XNt4b2 in4 en4b2 top4b2 vss sky130_fd_pr__nfet_01v8 W=0.84u L=0.15u
XPt4b2 in4 en4b2b top4b2 vdd sky130_fd_pr__pfet_01v8 W=1.68u L=0.15u
XC4b2 top4b2 vss sky130_fd_pr__cap_mim_m3_1 W=9.63 L=9.63 MF=1
XNe4b2 top4b2 phi_e bl vss sky130_fd_pr__nfet_01v8 W=0.84u L=0.15u
XPe4b2 top4b2 phi_eb bl vdd sky130_fd_pr__pfet_01v8 W=1.68u L=0.15u
XNr4b2 top4b2 phi_r vss vss sky130_fd_pr__nfet_01v8 W=0.42u L=0.15u

* --- INPUT 4, BIT 3 (8×Cunit ≈ 400.0fF MIM, W=13.77 L=13.77) ---
XNt4b3 in4 en4b3 top4b3 vss sky130_fd_pr__nfet_01v8 W=0.84u L=0.15u
XPt4b3 in4 en4b3b top4b3 vdd sky130_fd_pr__pfet_01v8 W=1.68u L=0.15u
XC4b3 top4b3 vss sky130_fd_pr__cap_mim_m3_1 W=13.77 L=13.77 MF=1
XNe4b3 top4b3 phi_e bl vss sky130_fd_pr__nfet_01v8 W=0.84u L=0.15u
XPe4b3 top4b3 phi_eb bl vdd sky130_fd_pr__pfet_01v8 W=1.68u L=0.15u
XNr4b3 top4b3 phi_r vss vss sky130_fd_pr__nfet_01v8 W=0.42u L=0.15u

* --- INPUT 5, BIT 0 (1×Cunit ≈ 50.0fF MIM, W=4.63 L=4.63) ---
XNt5b0 in5 en5b0 top5b0 vss sky130_fd_pr__nfet_01v8 W=0.84u L=0.15u
XPt5b0 in5 en5b0b top5b0 vdd sky130_fd_pr__pfet_01v8 W=1.68u L=0.15u
XC5b0 top5b0 vss sky130_fd_pr__cap_mim_m3_1 W=4.63 L=4.63 MF=1
XNe5b0 top5b0 phi_e bl vss sky130_fd_pr__nfet_01v8 W=0.84u L=0.15u
XPe5b0 top5b0 phi_eb bl vdd sky130_fd_pr__pfet_01v8 W=1.68u L=0.15u
XNr5b0 top5b0 phi_r vss vss sky130_fd_pr__nfet_01v8 W=0.42u L=0.15u

* --- INPUT 5, BIT 1 (2×Cunit ≈ 100.0fF MIM, W=6.7 L=6.7) ---
XNt5b1 in5 en5b1 top5b1 vss sky130_fd_pr__nfet_01v8 W=0.84u L=0.15u
XPt5b1 in5 en5b1b top5b1 vdd sky130_fd_pr__pfet_01v8 W=1.68u L=0.15u
XC5b1 top5b1 vss sky130_fd_pr__cap_mim_m3_1 W=6.7 L=6.7 MF=1
XNe5b1 top5b1 phi_e bl vss sky130_fd_pr__nfet_01v8 W=0.84u L=0.15u
XPe5b1 top5b1 phi_eb bl vdd sky130_fd_pr__pfet_01v8 W=1.68u L=0.15u
XNr5b1 top5b1 phi_r vss vss sky130_fd_pr__nfet_01v8 W=0.42u L=0.15u

* --- INPUT 5, BIT 2 (4×Cunit ≈ 200.0fF MIM, W=9.63 L=9.63) ---
XNt5b2 in5 en5b2 top5b2 vss sky130_fd_pr__nfet_01v8 W=0.84u L=0.15u
XPt5b2 in5 en5b2b top5b2 vdd sky130_fd_pr__pfet_01v8 W=1.68u L=0.15u
XC5b2 top5b2 vss sky130_fd_pr__cap_mim_m3_1 W=9.63 L=9.63 MF=1
XNe5b2 top5b2 phi_e bl vss sky130_fd_pr__nfet_01v8 W=0.84u L=0.15u
XPe5b2 top5b2 phi_eb bl vdd sky130_fd_pr__pfet_01v8 W=1.68u L=0.15u
XNr5b2 top5b2 phi_r vss vss sky130_fd_pr__nfet_01v8 W=0.42u L=0.15u

* --- INPUT 5, BIT 3 (8×Cunit ≈ 400.0fF MIM, W=13.77 L=13.77) ---
XNt5b3 in5 en5b3 top5b3 vss sky130_fd_pr__nfet_01v8 W=0.84u L=0.15u
XPt5b3 in5 en5b3b top5b3 vdd sky130_fd_pr__pfet_01v8 W=1.68u L=0.15u
XC5b3 top5b3 vss sky130_fd_pr__cap_mim_m3_1 W=13.77 L=13.77 MF=1
XNe5b3 top5b3 phi_e bl vss sky130_fd_pr__nfet_01v8 W=0.84u L=0.15u
XPe5b3 top5b3 phi_eb bl vdd sky130_fd_pr__pfet_01v8 W=1.68u L=0.15u
XNr5b3 top5b3 phi_r vss vss sky130_fd_pr__nfet_01v8 W=0.42u L=0.15u

* --- INPUT 6, BIT 0 (1×Cunit ≈ 50.0fF MIM, W=4.63 L=4.63) ---
XNt6b0 in6 en6b0 top6b0 vss sky130_fd_pr__nfet_01v8 W=0.84u L=0.15u
XPt6b0 in6 en6b0b top6b0 vdd sky130_fd_pr__pfet_01v8 W=1.68u L=0.15u
XC6b0 top6b0 vss sky130_fd_pr__cap_mim_m3_1 W=4.63 L=4.63 MF=1
XNe6b0 top6b0 phi_e bl vss sky130_fd_pr__nfet_01v8 W=0.84u L=0.15u
XPe6b0 top6b0 phi_eb bl vdd sky130_fd_pr__pfet_01v8 W=1.68u L=0.15u
XNr6b0 top6b0 phi_r vss vss sky130_fd_pr__nfet_01v8 W=0.42u L=0.15u

* --- INPUT 6, BIT 1 (2×Cunit ≈ 100.0fF MIM, W=6.7 L=6.7) ---
XNt6b1 in6 en6b1 top6b1 vss sky130_fd_pr__nfet_01v8 W=0.84u L=0.15u
XPt6b1 in6 en6b1b top6b1 vdd sky130_fd_pr__pfet_01v8 W=1.68u L=0.15u
XC6b1 top6b1 vss sky130_fd_pr__cap_mim_m3_1 W=6.7 L=6.7 MF=1
XNe6b1 top6b1 phi_e bl vss sky130_fd_pr__nfet_01v8 W=0.84u L=0.15u
XPe6b1 top6b1 phi_eb bl vdd sky130_fd_pr__pfet_01v8 W=1.68u L=0.15u
XNr6b1 top6b1 phi_r vss vss sky130_fd_pr__nfet_01v8 W=0.42u L=0.15u

* --- INPUT 6, BIT 2 (4×Cunit ≈ 200.0fF MIM, W=9.63 L=9.63) ---
XNt6b2 in6 en6b2 top6b2 vss sky130_fd_pr__nfet_01v8 W=0.84u L=0.15u
XPt6b2 in6 en6b2b top6b2 vdd sky130_fd_pr__pfet_01v8 W=1.68u L=0.15u
XC6b2 top6b2 vss sky130_fd_pr__cap_mim_m3_1 W=9.63 L=9.63 MF=1
XNe6b2 top6b2 phi_e bl vss sky130_fd_pr__nfet_01v8 W=0.84u L=0.15u
XPe6b2 top6b2 phi_eb bl vdd sky130_fd_pr__pfet_01v8 W=1.68u L=0.15u
XNr6b2 top6b2 phi_r vss vss sky130_fd_pr__nfet_01v8 W=0.42u L=0.15u

* --- INPUT 6, BIT 3 (8×Cunit ≈ 400.0fF MIM, W=13.77 L=13.77) ---
XNt6b3 in6 en6b3 top6b3 vss sky130_fd_pr__nfet_01v8 W=0.84u L=0.15u
XPt6b3 in6 en6b3b top6b3 vdd sky130_fd_pr__pfet_01v8 W=1.68u L=0.15u
XC6b3 top6b3 vss sky130_fd_pr__cap_mim_m3_1 W=13.77 L=13.77 MF=1
XNe6b3 top6b3 phi_e bl vss sky130_fd_pr__nfet_01v8 W=0.84u L=0.15u
XPe6b3 top6b3 phi_eb bl vdd sky130_fd_pr__pfet_01v8 W=1.68u L=0.15u
XNr6b3 top6b3 phi_r vss vss sky130_fd_pr__nfet_01v8 W=0.42u L=0.15u

* --- INPUT 7, BIT 0 (1×Cunit ≈ 50.0fF MIM, W=4.63 L=4.63) ---
XNt7b0 in7 en7b0 top7b0 vss sky130_fd_pr__nfet_01v8 W=0.84u L=0.15u
XPt7b0 in7 en7b0b top7b0 vdd sky130_fd_pr__pfet_01v8 W=1.68u L=0.15u
XC7b0 top7b0 vss sky130_fd_pr__cap_mim_m3_1 W=4.63 L=4.63 MF=1
XNe7b0 top7b0 phi_e bl vss sky130_fd_pr__nfet_01v8 W=0.84u L=0.15u
XPe7b0 top7b0 phi_eb bl vdd sky130_fd_pr__pfet_01v8 W=1.68u L=0.15u
XNr7b0 top7b0 phi_r vss vss sky130_fd_pr__nfet_01v8 W=0.42u L=0.15u

* --- INPUT 7, BIT 1 (2×Cunit ≈ 100.0fF MIM, W=6.7 L=6.7) ---
XNt7b1 in7 en7b1 top7b1 vss sky130_fd_pr__nfet_01v8 W=0.84u L=0.15u
XPt7b1 in7 en7b1b top7b1 vdd sky130_fd_pr__pfet_01v8 W=1.68u L=0.15u
XC7b1 top7b1 vss sky130_fd_pr__cap_mim_m3_1 W=6.7 L=6.7 MF=1
XNe7b1 top7b1 phi_e bl vss sky130_fd_pr__nfet_01v8 W=0.84u L=0.15u
XPe7b1 top7b1 phi_eb bl vdd sky130_fd_pr__pfet_01v8 W=1.68u L=0.15u
XNr7b1 top7b1 phi_r vss vss sky130_fd_pr__nfet_01v8 W=0.42u L=0.15u

* --- INPUT 7, BIT 2 (4×Cunit ≈ 200.0fF MIM, W=9.63 L=9.63) ---
XNt7b2 in7 en7b2 top7b2 vss sky130_fd_pr__nfet_01v8 W=0.84u L=0.15u
XPt7b2 in7 en7b2b top7b2 vdd sky130_fd_pr__pfet_01v8 W=1.68u L=0.15u
XC7b2 top7b2 vss sky130_fd_pr__cap_mim_m3_1 W=9.63 L=9.63 MF=1
XNe7b2 top7b2 phi_e bl vss sky130_fd_pr__nfet_01v8 W=0.84u L=0.15u
XPe7b2 top7b2 phi_eb bl vdd sky130_fd_pr__pfet_01v8 W=1.68u L=0.15u
XNr7b2 top7b2 phi_r vss vss sky130_fd_pr__nfet_01v8 W=0.42u L=0.15u

* --- INPUT 7, BIT 3 (8×Cunit ≈ 400.0fF MIM, W=13.77 L=13.77) ---
XNt7b3 in7 en7b3 top7b3 vss sky130_fd_pr__nfet_01v8 W=0.84u L=0.15u
XPt7b3 in7 en7b3b top7b3 vdd sky130_fd_pr__pfet_01v8 W=1.68u L=0.15u
XC7b3 top7b3 vss sky130_fd_pr__cap_mim_m3_1 W=13.77 L=13.77 MF=1
XNe7b3 top7b3 phi_e bl vss sky130_fd_pr__nfet_01v8 W=0.84u L=0.15u
XPe7b3 top7b3 phi_eb bl vdd sky130_fd_pr__pfet_01v8 W=1.68u L=0.15u
XNr7b3 top7b3 phi_r vss vss sky130_fd_pr__nfet_01v8 W=0.42u L=0.15u

* --- Bitline reset + routing parasitic ---
XNblrst bl phi_r vss vss sky130_fd_pr__nfet_01v8 W=0.84u L=0.15u
Cpar bl vss 80f

.ends mac_8in4b

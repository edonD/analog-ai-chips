** VibroSense Block 06: MAC Linearity Base Testbench
** Charge-domain MAC: bottom-plate sampling topology
**
** Key fix: cap_bot must be held at fixed potential during sample phase
** (otherwise both plates float together and no differential charge builds up)
**
** Correct topology:
**   Reset (s_resetb=LOW): cap_top=Vcm, cap_bot=Vcm (PFET precharge)
**   Sample (s_samp=HIGH):
**     - cap_top charged to Vinp via TG
**     - cap_bot held at Vcm via PFET (same precharge switch stays on during sample!)
**     Wait - but then when eval tries to change cap_bot, the PFET fights it.
**
** SIMPLEST CORRECT APPROACH (standard SAR ADC):
**   - Use s_samp also to hold cap_bot to Vcm via NFET to Vcm node
**   - s_samp=HIGH → cap_bot grounded to Vcm, cap_top charged to Vinp
**   - s_samp=LOW → cap_bot floats, eval switch connects cap_bot to bitline
**
** Implementation:
**   cap_bot_hold: NFET gate=s_samp, drain=cap_bot, source=vcm
**   eval: NFET gate=(s_eval*WB), drain=bl, source=cap_bot

.lib "sky130_local.lib" tt

.param Vcm_val = 0.9
.param Vinp_val = 1.05

** Weight bits substituted by runner
.param WB3 = %%WB3%%
.param WB2 = %%WB2%%
.param WB1 = %%WB1%%
.param WB0 = %%WB0%%

Vvdd vdd 0 dc 1.8
Vinp inp 0 dc {Vinp_val}
Vvcm vcm_src 0 dc {Vcm_val}

** ===== Clocks =====
** s_resetb: LOW=0V during reset (0-90ns), HIGH=1.8V after
** s_samp: LOW=0V at start, HIGH=1.8V during sample (100-300ns)
** s_sampb: complement
** s_eval: HIGH=1.8V during eval (310-510ns)
Vs_resetb s_resetb 0  PULSE(0   1.8  0n   1n 1n 90n  600n)
Vs_samp   s_samp   0  PULSE(0   1.8  100n 5n 5n 200n 600n)
Vs_sampb  s_sampb  0  PULSE(1.8 0    100n 5n 5n 200n 600n)
Vs_eval   s_eval   0  PULSE(0   1.8  310n 5n 5n 200n 600n)

** ===== Bitline =====
Cbl bl 0 1e-12
** Bitline precharge to Vcm during reset (s_resetb=LOW → PFET ON)
MP_bl bl s_resetb vcm_src vdd sky130_fd_pr__pfet_01v8__model W=8e-6 L=1.5e-7 nf=2

** ===== 4-Bit Binary-Weighted Cap Bank =====
**
** For each bit N:
**   MP_rtN: cap_top precharge to Vcm (gate=s_resetb, LOW=ON during reset)
**   TG_sN:  sample switch (cap_top <- inp, active during s_samp)
**   caps:   between cap_top and cap_bot
**   MN_hN:  cap_bot hold switch (cap_bot <- Vcm, gate=s_samp, active during sample)
**            This is KEY: holds cap_bot to Vcm while cap_top charges to Vinp
**   MN_eN:  eval switch (cap_bot -> bl, gate=s_eval*WBN)

** ===== Bit 3 (8 x 50fF = 400fF) =====
** Cap top precharge during reset
MP_rt3 cap3_top s_resetb vcm_src vdd sky130_fd_pr__pfet_01v8__model W=4e-6 L=1.5e-7 nf=1
** Sample TG: cap_top charged to Vinp
MN_s3  cap3_top s_samp   inp 0   sky130_fd_pr__nfet_01v8__model W=2e-6 L=1.5e-7 nf=1
MP_s3  cap3_top s_sampb  inp vdd sky130_fd_pr__pfet_01v8__model W=4e-6 L=1.5e-7 nf=1
** 8 caps (8 x 50fF = 400fF)
C3a cap3_top cap3_bot 50e-15
C3b cap3_top cap3_bot 50e-15
C3c cap3_top cap3_bot 50e-15
C3d cap3_top cap3_bot 50e-15
C3e cap3_top cap3_bot 50e-15
C3f cap3_top cap3_bot 50e-15
C3g cap3_top cap3_bot 50e-15
C3h cap3_top cap3_bot 50e-15
** Cap_bot hold to Vcm during reset AND sample (active when s_samp=HIGH or reset)
** Use: NFET to Vcm during sample (gate=s_samp)
** Also PFET during reset (gate=s_resetb)
MN_h3  cap3_bot s_samp   vcm_src 0 sky130_fd_pr__nfet_01v8__model W=4e-6 L=1.5e-7 nf=1
MP_h3b cap3_bot s_resetb vcm_src vdd sky130_fd_pr__pfet_01v8__model W=4e-6 L=1.5e-7 nf=1
** Eval switch: cap_bot -> bl (weight-gated by B-source: WBN * s_eval)
Bs_e3  s_eval3 0 V = {WB3} * V(s_eval)
MN_e3  bl s_eval3 cap3_bot 0 sky130_fd_pr__nfet_01v8__model W=4e-6 L=1.5e-7 nf=1

** ===== Bit 2 (4 x 50fF = 200fF) =====
MP_rt2 cap2_top s_resetb vcm_src vdd sky130_fd_pr__pfet_01v8__model W=4e-6 L=1.5e-7 nf=1
MN_s2  cap2_top s_samp   inp 0   sky130_fd_pr__nfet_01v8__model W=2e-6 L=1.5e-7 nf=1
MP_s2  cap2_top s_sampb  inp vdd sky130_fd_pr__pfet_01v8__model W=4e-6 L=1.5e-7 nf=1
C2a cap2_top cap2_bot 50e-15
C2b cap2_top cap2_bot 50e-15
C2c cap2_top cap2_bot 50e-15
C2d cap2_top cap2_bot 50e-15
MN_h2  cap2_bot s_samp   vcm_src 0 sky130_fd_pr__nfet_01v8__model W=4e-6 L=1.5e-7 nf=1
MP_h2b cap2_bot s_resetb vcm_src vdd sky130_fd_pr__pfet_01v8__model W=4e-6 L=1.5e-7 nf=1
Bs_e2  s_eval2 0 V = {WB2} * V(s_eval)
MN_e2  bl s_eval2 cap2_bot 0 sky130_fd_pr__nfet_01v8__model W=4e-6 L=1.5e-7 nf=1

** ===== Bit 1 (2 x 50fF = 100fF) =====
MP_rt1 cap1_top s_resetb vcm_src vdd sky130_fd_pr__pfet_01v8__model W=4e-6 L=1.5e-7 nf=1
MN_s1  cap1_top s_samp   inp 0   sky130_fd_pr__nfet_01v8__model W=2e-6 L=1.5e-7 nf=1
MP_s1  cap1_top s_sampb  inp vdd sky130_fd_pr__pfet_01v8__model W=4e-6 L=1.5e-7 nf=1
C1a cap1_top cap1_bot 50e-15
C1b cap1_top cap1_bot 50e-15
MN_h1  cap1_bot s_samp   vcm_src 0 sky130_fd_pr__nfet_01v8__model W=4e-6 L=1.5e-7 nf=1
MP_h1b cap1_bot s_resetb vcm_src vdd sky130_fd_pr__pfet_01v8__model W=4e-6 L=1.5e-7 nf=1
Bs_e1  s_eval1 0 V = {WB1} * V(s_eval)
MN_e1  bl s_eval1 cap1_bot 0 sky130_fd_pr__nfet_01v8__model W=4e-6 L=1.5e-7 nf=1

** ===== Bit 0 (1 x 50fF = 50fF) =====
MP_rt0 cap0_top s_resetb vcm_src vdd sky130_fd_pr__pfet_01v8__model W=4e-6 L=1.5e-7 nf=1
MN_s0  cap0_top s_samp   inp 0   sky130_fd_pr__nfet_01v8__model W=2e-6 L=1.5e-7 nf=1
MP_s0  cap0_top s_sampb  inp vdd sky130_fd_pr__pfet_01v8__model W=4e-6 L=1.5e-7 nf=1
C0a cap0_top cap0_bot 50e-15
MN_h0  cap0_bot s_samp   vcm_src 0 sky130_fd_pr__nfet_01v8__model W=4e-6 L=1.5e-7 nf=1
MP_h0b cap0_bot s_resetb vcm_src vdd sky130_fd_pr__pfet_01v8__model W=4e-6 L=1.5e-7 nf=1
Bs_e0  s_eval0 0 V = {WB0} * V(s_eval)
MN_e0  bl s_eval0 cap0_bot 0 sky130_fd_pr__nfet_01v8__model W=4e-6 L=1.5e-7 nf=1

.tran 1n 520n

.control
  run
  meas tran vbl_result FIND V(bl) AT=450n
  meas tran vcap3_top_s FIND V(cap3_top) AT=280n
  meas tran vcap3_bot_s FIND V(cap3_bot) AT=280n
  meas tran vcap3_bot_e FIND V(cap3_bot) AT=420n
  echo "cap3_top at sample end: $&vcap3_top_s V"
  echo "cap3_bot at sample end: $&vcap3_bot_s V"
  echo "cap3_bot at eval:       $&vcap3_bot_e V"
  echo "VBL_RESULT=$&vbl_result"
  quit
.endc

.end

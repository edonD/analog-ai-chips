* VibroSense Block 06: Full 4-Class WTA Classifier
* 4 × MAC (8in4b) + 3 StrongARM comparators in binary tree
* Process: SKY130A | Supply: 1.8V
* Generated by gen_mac_8in4b.py

* Binary tree WTA:
*   Comp0: bl0 vs bl1 → winner01 (selects higher of class 0,1)
*   Comp1: bl2 vs bl3 → winner23 (selects higher of class 2,3)
*   Comp2: winner01 vs winner23 → final winner
*
* Output: 2-bit class code (class0=00, class1=01, class2=10, class3=11)
* For this testbench, we use the comparator outputs directly.

.subckt wta_2input vinp vinn voutp voutn clk vdd vss
* Simple WTA for 2 inputs using StrongARM
.include "strongarm_comp.spice"
XCOMP vinp vinn voutp voutn clk vdd vss strongarm_comp
.ends wta_2input

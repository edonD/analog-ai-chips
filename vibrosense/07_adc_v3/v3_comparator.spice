* ============================================================================
* Comparator v3 — Pre-Amplifier + StrongARM Dynamic Latch
* VibroSense 8-bit SAR ADC — Block 07
* Process: SkyWater SKY130A (130 nm CMOS), Supply: 1.8V
* ============================================================================
*
* v3 redesign rationale (from independent review of v2):
*   - v2 continuous diff-amp had 15mV systematic offset (3 LSB)
*   - Failed at SS corner (94mV offset!) and SF corner
*   - PMOS mirror W=2u was too narrow for current matching
*
* Architecture: Two-stage comparator
*   Stage 1: Continuous pre-amplifier (NMOS diff pair + PMOS mirror)
*     - Provides voltage gain of ~20-40x
*     - Reduces StrongARM input-referred offset by gain factor
*     - Always on during conversion (gated by sleep_n)
*   Stage 2: StrongARM dynamic latch (clocked by comp_clk)
*     - comp_clk LOW: RESET (precharge outputs to VDD)
*     - comp_clk HIGH: EVALUATE (regenerate to rail-to-rail)
*     - Decision time ~50-100ns for 1 LSB (4.7mV) input
*
* Output polarity:
*   outp = HIGH when inp < inn (vtop < vref → keep SAR bit)
*   outp = LOW  when inp > inn (vtop > vref → clear SAR bit)
*
* Timing with SAR logic:
*   CLK HIGH: DAC settles, pre-amp tracks, latch in RESET (comp_clk LOW)
*   CLK LOW:  comp_clk HIGH → latch EVALUATES, output valid
*   CLK rises: DFF captures latch output BEFORE comp_clk drops (~1ns margin)
*
* ============================================================================

.subckt v3_comparator inp inn outp outn vdd vss comp_clk sleep_n

* --- Power gating ---
* PMOS header controlled by sleep_n (active-low sleep)
M_slp_n sleep_bar sleep_n vss vss sky130_fd_pr__nfet_01v8__model w=1u l=0.15u
M_slp_p sleep_bar sleep_n vdd vdd sky130_fd_pr__pfet_01v8__model w=2u l=0.15u
M_pg vdd_int sleep_bar vdd vdd sky130_fd_pr__pfet_01v8__model w=10u l=0.15u

* --- Bias generation (~5-6uA) ---
M_bias vbias vbias vss vss sky130_fd_pr__nfet_01v8__model w=2u l=2u
Rbias vdd_int vbias 200k

* --- Stage 1: Pre-amplifier (continuous, always on when awake) ---
* Tail current source (mirrors bias, W/L ratio gives ~2x Ibias)
M_tail1 tail1 vbias vss vss sky130_fd_pr__nfet_01v8__model w=4u l=2u

* NMOS input differential pair (large W*L for low random offset)
M_n1 d1n inp tail1 vss sky130_fd_pr__nfet_01v8__model w=8u l=1u
M_n2 d1p inn tail1 vss sky130_fd_pr__nfet_01v8__model w=8u l=1u

* PMOS current mirror load (WIDER than v2's 2u — fixes SF corner)
* M_p1 is diode-connected (reference), M_p2 mirrors current to d1p
M_p1 d1n d1n vdd_int vdd_int sky130_fd_pr__pfet_01v8__model w=4u l=1u
M_p2 d1p d1n vdd_int vdd_int sky130_fd_pr__pfet_01v8__model w=4u l=1u

* --- Stage 2: StrongARM dynamic latch ---
* Topology: cross-coupled CMOS inverters + stacked input pair + tail switch
*
*         VDD_int                  VDD_int
*          |                        |
*         M_rst_p                  M_rst_n     (PMOS reset, gate=comp_clk)
*          |                        |
*         M_lp1(gate=outn_i)       M_lp2(gate=outp_i)  (PMOS latch)
*          |                        |
*         outp_i                   outn_i
*          |                        |
*         M_ln1(gate=outn_i)       M_ln2(gate=outp_i)  (NMOS latch)
*          |                        |
*         M_in1(gate=d1p)          M_in2(gate=d1n)     (NMOS input pair)
*          |                        |
*          +--------tail2----------+
*                     |
*                   M_tail2(gate=comp_clk)
*                     |
*                    VSS

* Tail current switch (enables evaluation when comp_clk = HIGH)
M_tail2 tail2 comp_clk vss vss sky130_fd_pr__nfet_01v8__model w=4u l=0.15u

* NMOS input pair (driven by pre-amp differential outputs)
* d1p rises when inp > inn → M_in1 draws more current → outp_i drops
M_in1 sn1 d1p tail2 vss sky130_fd_pr__nfet_01v8__model w=4u l=0.5u
M_in2 sn2 d1n tail2 vss sky130_fd_pr__nfet_01v8__model w=4u l=0.5u

* NMOS cross-coupled latch
M_ln1 outp_i outn_i sn1 vss sky130_fd_pr__nfet_01v8__model w=2u l=0.15u
M_ln2 outn_i outp_i sn2 vss sky130_fd_pr__nfet_01v8__model w=2u l=0.15u

* PMOS cross-coupled latch
M_lp1 outp_i outn_i vdd_int vdd_int sky130_fd_pr__pfet_01v8__model w=2u l=0.15u
M_lp2 outn_i outp_i vdd_int vdd_int sky130_fd_pr__pfet_01v8__model w=2u l=0.15u

* PMOS reset switches (precharge to VDD when comp_clk = LOW)
M_rst_p outp_i comp_clk vdd_int vdd_int sky130_fd_pr__pfet_01v8__model w=2u l=0.15u
M_rst_n outn_i comp_clk vdd_int vdd_int sky130_fd_pr__pfet_01v8__model w=2u l=0.15u

* --- SR Latch: holds comparator decision through StrongARM reset ---
* Required for FF/SF corners where the StrongARM resets too fast.
* The delayed valid signal (10ns) in the SAR logic ensures the DFF reads
* the DECIDED d0 value (not the stale tentative), fixing the bit 0 issue.
M_sr1_p1 q_sr outn_i vdd_int vdd_int sky130_fd_pr__pfet_01v8__model w=2u l=0.15u
M_sr1_p2 q_sr qbar_sr vdd_int vdd_int sky130_fd_pr__pfet_01v8__model w=2u l=0.15u
M_sr1_n1 q_sr outn_i mid_sr1 vss sky130_fd_pr__nfet_01v8__model w=2u l=0.15u
M_sr1_n2 mid_sr1 qbar_sr vss vss sky130_fd_pr__nfet_01v8__model w=2u l=0.15u

M_sr2_p1 qbar_sr outp_i vdd_int vdd_int sky130_fd_pr__pfet_01v8__model w=2u l=0.15u
M_sr2_p2 qbar_sr q_sr vdd_int vdd_int sky130_fd_pr__pfet_01v8__model w=2u l=0.15u
M_sr2_n1 qbar_sr outp_i mid_sr2 vss sky130_fd_pr__nfet_01v8__model w=2u l=0.15u
M_sr2_n2 mid_sr2 q_sr vss vss sky130_fd_pr__nfet_01v8__model w=2u l=0.15u

* --- Output buffers (non-inverting from SR latch) ---
M_inv1_n mid_p q_sr vss vss sky130_fd_pr__nfet_01v8__model w=2u l=0.15u
M_inv1_p mid_p q_sr vdd_int vdd_int sky130_fd_pr__pfet_01v8__model w=4u l=0.15u
M_inv2_n outp mid_p vss vss sky130_fd_pr__nfet_01v8__model w=2u l=0.15u
M_inv2_p outp mid_p vdd_int vdd_int sky130_fd_pr__pfet_01v8__model w=4u l=0.15u

M_inv3_n mid_n qbar_sr vss vss sky130_fd_pr__nfet_01v8__model w=2u l=0.15u
M_inv3_p mid_n qbar_sr vdd_int vdd_int sky130_fd_pr__pfet_01v8__model w=4u l=0.15u
M_inv4_n outn mid_n vss vss sky130_fd_pr__nfet_01v8__model w=2u l=0.15u
M_inv4_p outn mid_n vdd_int vdd_int sky130_fd_pr__pfet_01v8__model w=4u l=0.15u

.ends v3_comparator

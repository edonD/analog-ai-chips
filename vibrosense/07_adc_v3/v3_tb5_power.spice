* TB5: Active Power Measurement
* Measures average supply current during conversion

.include sky130_pdk_fixup.spice
.lib sky130_v3.lib.spice tt

.include v3_cap_dac.spice
.include v3_comparator.spice
.include v3_sar_logic.spice
.include v3_sar_adc.spice

VDD vdd 0 1.8
VSS vss 0 0
Vref vref 0 1.2
Vin vin 0 0.6

Vclk clk 0 PULSE(0 1.8 5u 10n 10n 5u 10u)
Vconv convert 0 PWL(0 0 14.9u 0 15u 1.8)
Vslp sleep_n 0 1.8

Xadc vin vref clk convert sleep_n
+ d7 d6 d5 d4 d3 d2 d1 d0 valid
+ vdd vss v3_sar_adc

.tran 100n 130u

* Measure average current during conversion (15us to 115us)
.meas tran Iavg AVG i(VDD) FROM=20u TO=110u
.meas tran Pavg PARAM='-Iavg*1.8'

.control
run
echo "=== TB5: Active Power ==="
print Iavg Pavg
.endc

.end

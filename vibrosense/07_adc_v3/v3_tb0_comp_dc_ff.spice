* TB0: Comparator Pre-Amp DC Sweep — Offset Measurement
* Measures pre-amp offset at actual ADC operating point (Vcm near Vref=1.2V)
* Pre-amp offset dominates total comparator offset (StrongARM offset / gain)

.include sky130_pdk_fixup.spice
.lib sky130_v3.lib.spice ff

.include v3_comparator.spice

* Supply
VDD vdd 0 1.8
VSS vss 0 0

* Comparator instance
Xcomp inp inn outp outn vdd vss comp_clk sleep_n v3_comparator

* Inputs — sweep inp around inn=1.2V
Vinn inn 0 1.2
Vinp inp 0 1.2

* comp_clk = LOW for pre-amp DC test (latch in reset, outputs at VDD)
* We measure pre-amp differential output d1p vs d1n
Vclk comp_clk 0 0

* sleep_n = HIGH (awake)
Vslp sleep_n 0 1.8

* DC sweep
.dc Vinp 1.15 1.25 0.1m

* Measure pre-amp offset: find inp where d1p crosses d1n
.meas dc vos_preamp FIND v(inp) WHEN v(Xcomp.d1p)=v(Xcomp.d1n)
.meas dc offset_mv PARAM='(vos_preamp-1.2)*1000'
.meas dc preamp_gain DERIV v(Xcomp.d1p) AT=1.2

.control
run
wrdata v3_comp_dc_ff.dat v(Xcomp.d1p) v(Xcomp.d1n)
.endc

.end

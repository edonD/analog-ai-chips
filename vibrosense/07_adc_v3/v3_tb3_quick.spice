* TB3 Quick: DNL/INL with 256 conversions (fast estimate)
* Same as TB3 but fewer points — runs ~8x faster

.include sky130_pdk_fixup.spice
.lib sky130_v3.lib.spice tt

.include v3_cap_dac.spice
.include v3_comparator.spice
.include v3_sar_logic.spice
.include v3_sar_adc.spice

VDD vdd 0 1.8
VSS vss 0 0
Vref vref 0 1.2

* Ramp from 0V to 1.2V over 256 conversions
* At 5MHz, 10 clk/conv = 2us/conv
* 256 conversions × 2us = 512us = 0.512ms
* Ramp time slightly longer to include startup
Vin vin 0 PWL(0 0 0.55m 1.2)

* Clock: 5MHz
Vclk clk 0 PULSE(0 1.8 100n 5n 5n 100n 200n)

* Convert: HIGH at 300ns
Vconv convert 0 PWL(0 0 299n 0 300n 1.8)

* Sleep: awake
Vslp sleep_n 0 1.8

Xadc vin vref clk convert sleep_n
+ d7 d6 d5 d4 d3 d2 d1 d0 valid
+ vdd vss v3_sar_adc

.save v(d7) v(d6) v(d5) v(d4) v(d3) v(d2) v(d1) v(d0) v(valid)

.tran 50n 0.55m

.control
run
wrdata v3_tb3_quick.dat v(d7) v(d6) v(d5) v(d4) v(d3) v(d2) v(d1) v(d0) v(valid)
.endc

.end

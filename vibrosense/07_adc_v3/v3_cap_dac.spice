* ============================================================================
* 8-bit Binary-Weighted Capacitor DAC — v2 (Tape-Out Quality)
* VibroSense SAR ADC — Block 07
* Process: SkyWater SKY130A (130 nm CMOS)
* ============================================================================
*
* v2 changes from v1:
*   - ALL switches replaced with real SKY130 CMOS transmission gates
*   - No ideal SWMOD switches, no E-source inverters
*   - Uses direct MOSFET model instantiation for maximum compatibility
*   - Capacitors use ideal C elements (documented approximation — SKY130 MIM
*     cap models not available in minimal PDK; parasitic Cbot ~10% expected)
*
* Architecture: Single-ended binary-weighted charge redistribution DAC
*   - 8 binary-weighted caps: 1C, 2C, 4C, 8C, 16C, 32C, 64C, 128C
*   - 1 dummy cap (1C) tied to GND
*   - Total: 256 * Cunit = 5.12 pF (Cunit = 20 fF)
*   - Bottom-plate switching between Vref and GND via CMOS TG
*
* Switch sizing:
*   NMOS: W=1u, L=0.15u -> Ron_n ~ 500 ohm
*   PMOS: W=2u, L=0.15u -> Ron_p ~ 500 ohm
*   TG parallel Ron ~ 250 ohm
*   Settling: 5*tau = 5 * 250 * 5.12p = 6.4 ns << 10 us clock
*
* ============================================================================

* --- Bottom-Plate Bit Switch (CMOS Transmission Gate) ---
* When ctrl=HIGH (ctrl_b=LOW): connects bottom plate to Vref
* When ctrl=LOW (ctrl_b=HIGH): connects bottom plate to GND
*
.subckt bit_sw bp vref gnd_node ctrl ctrl_b vdd vss
* TG to Vref: ON when ctrl=HIGH, ctrl_b=LOW
M_vr_n vref ctrl  bp vss sky130_fd_pr__nfet_01v8__model w=1u l=0.15u
M_vr_p vref ctrl_b bp vdd sky130_fd_pr__pfet_01v8__model w=2u l=0.15u
* TG to GND: ON when ctrl=LOW, ctrl_b=HIGH
M_gn_n gnd_node ctrl_b bp vss sky130_fd_pr__nfet_01v8__model w=1u l=0.15u
M_gn_p gnd_node ctrl   bp vdd sky130_fd_pr__pfet_01v8__model w=2u l=0.15u
.ends bit_sw

* --- 8-bit Cap DAC with Real Switches ---
*
.subckt v2_cap_dac_8b top vref gnd_node
+ sw7 sw7_b sw6 sw6_b sw5 sw5_b sw4 sw4_b
+ sw3 sw3_b sw2 sw2_b sw1 sw1_b sw0 sw0_b
+ vdd vss
+ Cunit=20f

* Binary-weighted capacitors (top plate is common node)
C128 top bn7 {128*Cunit}
C64  top bn6 {64*Cunit}
C32  top bn5 {32*Cunit}
C16  top bn4 {16*Cunit}
C8   top bn3 {8*Cunit}
C4   top bn2 {4*Cunit}
C2   top bn1 {2*Cunit}
C1   top bn0 {1*Cunit}

* Dummy capacitor (always connected to GND)
Cdummy top gnd_node {1*Cunit}

* Bottom-plate switches — real CMOS transmission gates
Xsw7 bn7 vref gnd_node sw7 sw7_b vdd vss bit_sw
Xsw6 bn6 vref gnd_node sw6 sw6_b vdd vss bit_sw
Xsw5 bn5 vref gnd_node sw5 sw5_b vdd vss bit_sw
Xsw4 bn4 vref gnd_node sw4 sw4_b vdd vss bit_sw
Xsw3 bn3 vref gnd_node sw3 sw3_b vdd vss bit_sw
Xsw2 bn2 vref gnd_node sw2 sw2_b vdd vss bit_sw
Xsw1 bn1 vref gnd_node sw1 sw1_b vdd vss bit_sw
Xsw0 bn0 vref gnd_node sw0 sw0_b vdd vss bit_sw

* DC convergence aids: high-value resistors on floating nodes
Rleak7 bn7 gnd_node 10G
Rleak6 bn6 gnd_node 10G
Rleak5 bn5 gnd_node 10G
Rleak4 bn4 gnd_node 10G
Rleak3 bn3 gnd_node 10G
Rleak2 bn2 gnd_node 10G
Rleak1 bn1 gnd_node 10G
Rleak0 bn0 gnd_node 10G
* v3: Increased from 10G to 100G to reduce charge leakage during conversion
* At 10G, 120pA leaks from vtop during 100us conversion = 12fC = 0.5 LSB error
* At 100G, leakage drops to 0.05 LSB — negligible
Rleak_top top gnd_node 100G

.ends v2_cap_dac_8b

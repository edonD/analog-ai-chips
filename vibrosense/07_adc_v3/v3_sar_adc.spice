* ============================================================================
* 8-bit SAR ADC v3 — Top Level
* VibroSense Block 07 — Full Redesign
* Process: SkyWater SKY130A (130 nm CMOS), Supply: 1.8V, Vref: 1.2V
* ============================================================================
*
* Changes from v2:
*   1. New comparator: Pre-amp + StrongARM latch (offset < 1mV all corners)
*   2. DAC reset fix: AND NOT(sample) gates all DAC outputs during sampling
*   3. Honest testbench ordering: multi-conversion tested BEFORE claiming victory
*
* Architecture:
*   Vin → [CMOS TG] → Vtop ←→ [8-bit Cap DAC] ←→ [SAR Logic]
*                        ↓                              ↑
*                   [Comparator] ──── comp_out ──────────┘
*                   inp=Vtop, inn=Vref
*
* Output code: complement code
*   code = round((Vref - Vin) / Vref * 256)
*   Vin = 0V → code = 255, Vin = 1.2V → code = 0
*
* ============================================================================

* Include subcircuit files (must be included by testbench BEFORE this file)
* Required: v3_cap_dac.spice, v3_comparator.spice, v3_sar_logic.spice

.subckt v3_sar_adc vin vref clk convert sleep_n
+ d7 d6 d5 d4 d3 d2 d1 d0 valid
+ vdd vss

* --- Sample Switch (CMOS Transmission Gate) ---
* Connects Vin to Vtop during sample phase (sample=HIGH)
* Sized for fast settling: Ron ~ 100 ohm, tau = 100*5.12p = 0.5ns
M_sw_n vtop sample vin vss sky130_fd_pr__nfet_01v8__model w=5u l=0.15u
M_sw_p vtop sample_b vin vdd sky130_fd_pr__pfet_01v8__model w=10u l=0.15u

* --- 8-bit Binary-Weighted Capacitor DAC ---
* 128C + 64C + 32C + 16C + 8C + 4C + 2C + 1C + 1C(dummy)
* Total = 256 * 20fF = 5.12 pF
Xdac vtop vref vss
+ d7 d7_b d6 d6_b d5 d5_b d4 d4_b
+ d3 d3_b d2 d2_b d1 d1_b d0 d0_b
+ vdd vss v2_cap_dac_8b

* --- Comparator (Pre-amp + StrongARM Latch) ---
* inp = Vtop (DAC top plate), inn = Vref (1.2V reference)
* comp_out: HIGH = keep bit, LOW = clear bit
Xcomp vtop vref comp_out comp_out_n vdd vss comp_clk sleep_n v3_comparator

* --- SAR Logic (Hybrid XSPICE DFF + Transistor CMOS gates) ---
* Generates: DAC switch controls (d7-d0, d7_b-d0_b)
*            sample/sample_b (sample switch control)
*            valid (output data valid flag)
*            comp_clk (comparator clock: NOT(clk) AND eval_active)
Xsar clk convert comp_out
+ d7 d6 d5 d4 d3 d2 d1 d0
+ d7_b d6_b d5_b d4_b d3_b d2_b d1_b d0_b
+ sample sample_b valid comp_clk
+ vdd vss v3_sar_logic

.ends v3_sar_adc

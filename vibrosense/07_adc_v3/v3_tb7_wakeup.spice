* TB7: Wakeup Time Measurement
* Measures time from sleep_n rising to first valid output

.include sky130_pdk_fixup.spice
.lib sky130_v3.lib.spice tt

.include v3_cap_dac.spice
.include v3_comparator.spice
.include v3_sar_logic.spice
.include v3_sar_adc.spice

VDD vdd 0 1.8
VSS vss 0 0
Vref vref 0 1.2
Vin vin 0 0.6

Vclk clk 0 PULSE(0 1.8 5u 10n 10n 5u 10u)

* Sleep for first 20us, then wake up
Vslp sleep_n 0 PWL(0 0 19.9u 0 20u 1.8)

* Convert goes HIGH after wakeup
Vconv convert 0 PWL(0 0 24.9u 0 25u 1.8)

Xadc vin vref clk convert sleep_n
+ d7 d6 d5 d4 d3 d2 d1 d0 valid
+ vdd vss v3_sar_adc

.tran 100n 200u

.meas tran t_wake WHEN v(sleep_n)=0.9 RISE=1
.meas tran t_valid WHEN v(valid)=0.9 RISE=1
.meas tran t_wakeup PARAM='t_valid-t_wake'

.control
run
echo "=== TB7: Wakeup Time ==="
print t_wake t_valid t_wakeup
.endc

.end

* TB2 at 5MHz: Quick settling check
* Same 13 voltages as TB2 but at 5MHz clock (accelerated)
* If settling is an issue, codes around MSB transitions will be wrong

.include sky130_pdk_fixup.spice
.lib sky130_v3.lib.spice tt

.include v3_cap_dac.spice
.include v3_comparator.spice
.include v3_sar_logic.spice
.include v3_sar_adc.spice

VDD vdd 0 1.8
VSS vss 0 0
Vref vref 0 1.2

* 13 voltages, each conversion = 2us at 5MHz (10 clks × 200ns)
* Change Vin during hold phase of each conversion
Vin vin 0 PWL(
+ 0     0.0
+ 0.9u  0.0
+ 1.0u  0.1
+ 2.9u  0.1
+ 3.0u  0.2
+ 4.9u  0.2
+ 5.0u  0.3
+ 6.9u  0.3
+ 7.0u  0.4
+ 8.9u  0.4
+ 9.0u  0.5
+ 10.9u 0.5
+ 11.0u 0.6
+ 12.9u 0.6
+ 13.0u 0.7
+ 14.9u 0.7
+ 15.0u 0.8
+ 16.9u 0.8
+ 17.0u 0.9
+ 18.9u 0.9
+ 19.0u 1.0
+ 20.9u 1.0
+ 21.0u 1.1
+ 22.9u 1.1
+ 23.0u 1.2
+ 28u   1.2)

* Clock: 5MHz
Vclk clk 0 PULSE(0 1.8 100n 5n 5n 100n 200n)

* Convert: HIGH at 300ns
Vconv convert 0 PWL(0 0 299n 0 300n 1.8)

Vslp sleep_n 0 1.8

Xadc vin vref clk convert sleep_n
+ d7 d6 d5 d4 d3 d2 d1 d0 valid
+ vdd vss v3_sar_adc

.tran 10n 28u

.meas tran v1_b7 FIND v(d7) WHEN v(valid)=0.9 RISE=1
.meas tran v1_b6 FIND v(d6) WHEN v(valid)=0.9 RISE=1
.meas tran v1_b5 FIND v(d5) WHEN v(valid)=0.9 RISE=1
.meas tran v1_b4 FIND v(d4) WHEN v(valid)=0.9 RISE=1
.meas tran v1_b3 FIND v(d3) WHEN v(valid)=0.9 RISE=1
.meas tran v1_b2 FIND v(d2) WHEN v(valid)=0.9 RISE=1
.meas tran v1_b1 FIND v(d1) WHEN v(valid)=0.9 RISE=1
.meas tran v1_b0 FIND v(d0) WHEN v(valid)=0.9 RISE=1

.meas tran v2_b7 FIND v(d7) WHEN v(valid)=0.9 RISE=2
.meas tran v2_b6 FIND v(d6) WHEN v(valid)=0.9 RISE=2
.meas tran v2_b5 FIND v(d5) WHEN v(valid)=0.9 RISE=2
.meas tran v2_b4 FIND v(d4) WHEN v(valid)=0.9 RISE=2
.meas tran v2_b3 FIND v(d3) WHEN v(valid)=0.9 RISE=2
.meas tran v2_b2 FIND v(d2) WHEN v(valid)=0.9 RISE=2
.meas tran v2_b1 FIND v(d1) WHEN v(valid)=0.9 RISE=2
.meas tran v2_b0 FIND v(d0) WHEN v(valid)=0.9 RISE=2

.meas tran v3_b7 FIND v(d7) WHEN v(valid)=0.9 RISE=3
.meas tran v3_b6 FIND v(d6) WHEN v(valid)=0.9 RISE=3
.meas tran v3_b5 FIND v(d5) WHEN v(valid)=0.9 RISE=3
.meas tran v3_b4 FIND v(d4) WHEN v(valid)=0.9 RISE=3
.meas tran v3_b3 FIND v(d3) WHEN v(valid)=0.9 RISE=3
.meas tran v3_b2 FIND v(d2) WHEN v(valid)=0.9 RISE=3
.meas tran v3_b1 FIND v(d1) WHEN v(valid)=0.9 RISE=3
.meas tran v3_b0 FIND v(d0) WHEN v(valid)=0.9 RISE=3

.meas tran v4_b7 FIND v(d7) WHEN v(valid)=0.9 RISE=4
.meas tran v4_b6 FIND v(d6) WHEN v(valid)=0.9 RISE=4
.meas tran v4_b5 FIND v(d5) WHEN v(valid)=0.9 RISE=4
.meas tran v4_b4 FIND v(d4) WHEN v(valid)=0.9 RISE=4
.meas tran v4_b3 FIND v(d3) WHEN v(valid)=0.9 RISE=4
.meas tran v4_b2 FIND v(d2) WHEN v(valid)=0.9 RISE=4
.meas tran v4_b1 FIND v(d1) WHEN v(valid)=0.9 RISE=4
.meas tran v4_b0 FIND v(d0) WHEN v(valid)=0.9 RISE=4

.meas tran v5_b7 FIND v(d7) WHEN v(valid)=0.9 RISE=5
.meas tran v5_b6 FIND v(d6) WHEN v(valid)=0.9 RISE=5
.meas tran v5_b5 FIND v(d5) WHEN v(valid)=0.9 RISE=5
.meas tran v5_b4 FIND v(d4) WHEN v(valid)=0.9 RISE=5
.meas tran v5_b3 FIND v(d3) WHEN v(valid)=0.9 RISE=5
.meas tran v5_b2 FIND v(d2) WHEN v(valid)=0.9 RISE=5
.meas tran v5_b1 FIND v(d1) WHEN v(valid)=0.9 RISE=5
.meas tran v5_b0 FIND v(d0) WHEN v(valid)=0.9 RISE=5

.meas tran v6_b7 FIND v(d7) WHEN v(valid)=0.9 RISE=6
.meas tran v6_b6 FIND v(d6) WHEN v(valid)=0.9 RISE=6
.meas tran v6_b5 FIND v(d5) WHEN v(valid)=0.9 RISE=6
.meas tran v6_b4 FIND v(d4) WHEN v(valid)=0.9 RISE=6
.meas tran v6_b3 FIND v(d3) WHEN v(valid)=0.9 RISE=6
.meas tran v6_b2 FIND v(d2) WHEN v(valid)=0.9 RISE=6
.meas tran v6_b1 FIND v(d1) WHEN v(valid)=0.9 RISE=6
.meas tran v6_b0 FIND v(d0) WHEN v(valid)=0.9 RISE=6

.meas tran v7_b7 FIND v(d7) WHEN v(valid)=0.9 RISE=7
.meas tran v7_b6 FIND v(d6) WHEN v(valid)=0.9 RISE=7
.meas tran v7_b5 FIND v(d5) WHEN v(valid)=0.9 RISE=7
.meas tran v7_b4 FIND v(d4) WHEN v(valid)=0.9 RISE=7
.meas tran v7_b3 FIND v(d3) WHEN v(valid)=0.9 RISE=7
.meas tran v7_b2 FIND v(d2) WHEN v(valid)=0.9 RISE=7
.meas tran v7_b1 FIND v(d1) WHEN v(valid)=0.9 RISE=7
.meas tran v7_b0 FIND v(d0) WHEN v(valid)=0.9 RISE=7

.meas tran v8_b7 FIND v(d7) WHEN v(valid)=0.9 RISE=8
.meas tran v8_b6 FIND v(d6) WHEN v(valid)=0.9 RISE=8
.meas tran v8_b5 FIND v(d5) WHEN v(valid)=0.9 RISE=8
.meas tran v8_b4 FIND v(d4) WHEN v(valid)=0.9 RISE=8
.meas tran v8_b3 FIND v(d3) WHEN v(valid)=0.9 RISE=8
.meas tran v8_b2 FIND v(d2) WHEN v(valid)=0.9 RISE=8
.meas tran v8_b1 FIND v(d1) WHEN v(valid)=0.9 RISE=8
.meas tran v8_b0 FIND v(d0) WHEN v(valid)=0.9 RISE=8

.meas tran v9_b7 FIND v(d7) WHEN v(valid)=0.9 RISE=9
.meas tran v9_b6 FIND v(d6) WHEN v(valid)=0.9 RISE=9
.meas tran v9_b5 FIND v(d5) WHEN v(valid)=0.9 RISE=9
.meas tran v9_b4 FIND v(d4) WHEN v(valid)=0.9 RISE=9
.meas tran v9_b3 FIND v(d3) WHEN v(valid)=0.9 RISE=9
.meas tran v9_b2 FIND v(d2) WHEN v(valid)=0.9 RISE=9
.meas tran v9_b1 FIND v(d1) WHEN v(valid)=0.9 RISE=9
.meas tran v9_b0 FIND v(d0) WHEN v(valid)=0.9 RISE=9

.meas tran v10_b7 FIND v(d7) WHEN v(valid)=0.9 RISE=10
.meas tran v10_b6 FIND v(d6) WHEN v(valid)=0.9 RISE=10
.meas tran v10_b5 FIND v(d5) WHEN v(valid)=0.9 RISE=10
.meas tran v10_b4 FIND v(d4) WHEN v(valid)=0.9 RISE=10
.meas tran v10_b3 FIND v(d3) WHEN v(valid)=0.9 RISE=10
.meas tran v10_b2 FIND v(d2) WHEN v(valid)=0.9 RISE=10
.meas tran v10_b1 FIND v(d1) WHEN v(valid)=0.9 RISE=10
.meas tran v10_b0 FIND v(d0) WHEN v(valid)=0.9 RISE=10

.meas tran v11_b7 FIND v(d7) WHEN v(valid)=0.9 RISE=11
.meas tran v11_b6 FIND v(d6) WHEN v(valid)=0.9 RISE=11
.meas tran v11_b5 FIND v(d5) WHEN v(valid)=0.9 RISE=11
.meas tran v11_b4 FIND v(d4) WHEN v(valid)=0.9 RISE=11
.meas tran v11_b3 FIND v(d3) WHEN v(valid)=0.9 RISE=11
.meas tran v11_b2 FIND v(d2) WHEN v(valid)=0.9 RISE=11
.meas tran v11_b1 FIND v(d1) WHEN v(valid)=0.9 RISE=11
.meas tran v11_b0 FIND v(d0) WHEN v(valid)=0.9 RISE=11

.meas tran v12_b7 FIND v(d7) WHEN v(valid)=0.9 RISE=12
.meas tran v12_b6 FIND v(d6) WHEN v(valid)=0.9 RISE=12
.meas tran v12_b5 FIND v(d5) WHEN v(valid)=0.9 RISE=12
.meas tran v12_b4 FIND v(d4) WHEN v(valid)=0.9 RISE=12
.meas tran v12_b3 FIND v(d3) WHEN v(valid)=0.9 RISE=12
.meas tran v12_b2 FIND v(d2) WHEN v(valid)=0.9 RISE=12
.meas tran v12_b1 FIND v(d1) WHEN v(valid)=0.9 RISE=12
.meas tran v12_b0 FIND v(d0) WHEN v(valid)=0.9 RISE=12

.meas tran v13_b7 FIND v(d7) WHEN v(valid)=0.9 RISE=13
.meas tran v13_b6 FIND v(d6) WHEN v(valid)=0.9 RISE=13
.meas tran v13_b5 FIND v(d5) WHEN v(valid)=0.9 RISE=13
.meas tran v13_b4 FIND v(d4) WHEN v(valid)=0.9 RISE=13
.meas tran v13_b3 FIND v(d3) WHEN v(valid)=0.9 RISE=13
.meas tran v13_b2 FIND v(d2) WHEN v(valid)=0.9 RISE=13
.meas tran v13_b1 FIND v(d1) WHEN v(valid)=0.9 RISE=13
.meas tran v13_b0 FIND v(d0) WHEN v(valid)=0.9 RISE=13

.control
run
echo "=== TB2 at 5MHz ==="
.endc

.end

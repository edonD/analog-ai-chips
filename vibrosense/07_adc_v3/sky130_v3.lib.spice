* SKY130 Full-Bin Library — NO subcircuit wrappers
.lib tt
.param mc_mm_switch = 0
.param mc_pr_switch = 0
.include "models/sky130_fd_pr__nfet_01v8__tt_standalone.spice"
.include "models/sky130_fd_pr__pfet_01v8__tt_standalone.spice"
.endl tt
.lib ss
.param mc_mm_switch = 0
.param mc_pr_switch = 0
.include "models/sky130_fd_pr__nfet_01v8__ss_standalone.spice"
.include "models/sky130_fd_pr__pfet_01v8__ss_standalone.spice"
.endl ss
.lib ff
.param mc_mm_switch = 0
.param mc_pr_switch = 0
.include "models/sky130_fd_pr__nfet_01v8__ff_standalone.spice"
.include "models/sky130_fd_pr__pfet_01v8__ff_standalone.spice"
.endl ff
.lib sf
.param mc_mm_switch = 0
.param mc_pr_switch = 0
.include "models/sky130_fd_pr__nfet_01v8__sf_standalone.spice"
.include "models/sky130_fd_pr__pfet_01v8__sf_standalone.spice"
.endl sf
.lib fs
.param mc_mm_switch = 0
.param mc_pr_switch = 0
.include "models/sky130_fd_pr__nfet_01v8__fs_standalone.spice"
.include "models/sky130_fd_pr__pfet_01v8__fs_standalone.spice"
.endl fs

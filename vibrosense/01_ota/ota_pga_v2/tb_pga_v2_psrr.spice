* TB: PGA OTA v2 PSRR — Power Supply Rejection Ratio
* Two-step measurement: (1) differential gain at 1kHz, (2) VDD-to-output gain at 1kHz
* PSRR = Adm(1kHz) - Avdd(1kHz) in dB
.option scale=1e-6
.lib "sky130_minimal_v2.lib.spice" tt
.include "ota_pga_v2.spice"

Vdd vdd 0 dc 1.8
Vbn  vbn  0 dc 0.65
Vbcn vbcn 0 dc 0.88
Vbp  vbp  0 dc 0.73
Vbcp vbcp 0 dc 0.475

* AC on non-inverting input (step 1: measure diff gain)
Vinn inn 0 dc 0.9 ac 1

* Loop-breaking: out -> inp (inverting)
Lbreak out inp 1G
Cdc inp 0 1

Xota vdd 0 inp inn out vbn vbcn vbp vbcp ota_pga_v2
CL out 0 10p

.ac dec 100 0.1 100Meg

.control
run

* Step 1: differential gain at 1kHz
meas ac adm_1k FIND vdb(out) AT=1000

* Save to shell variable (persists across reset)
set adm_saved = "$&adm_1k"

* Step 2: VDD-to-output gain
reset
alter Vinn ac = 0
alter Vdd ac = 1
run

meas ac avdd_1k FIND vdb(out) AT=1000

* Compute PSRR
let psrr = $adm_saved - avdd_1k

echo "adm_1k = $adm_saved"
echo "avdd_1k = $&avdd_1k"
echo "psrr_1k = $&psrr"

quit
.endc
.end

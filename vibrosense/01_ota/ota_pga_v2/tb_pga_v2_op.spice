* TB: PGA OTA v2 Operating Point Verification
* Two-stage Miller OTA — unity-gain feedback for DC stability
.option scale=1e-6
.lib "sky130_minimal_v2.lib.spice" tt
.include "ota_pga_v2.spice"

.param vdd_val = 1.8
.param vcm_val = 0.9

Vdd vdd 0 dc {vdd_val}

* Bias voltages (ideal sources)
Vbn  vbn  0 dc 0.65
Vbcn vbcn 0 dc 0.88
Vbp  vbp  0 dc 0.73
Vbcp vbcp 0 dc 0.475

* Unity-gain feedback: out → inp (inverting), signal → inn (non-inverting)
Vinn inn 0 dc {vcm_val}
Xota vdd 0 out inn out vbn vbcn vbp vbcp ota_pga_v2
CL out 0 10p

.nodeset v(out)=0.9

.op
.save all

.control
run

* M1 — input+ (NMOS, on diode mirror side)
let val = @m.xota.xm1.msky130_fd_pr__nfet_01v8[vgs]
echo "@m.xota.m1[vgs] = $&val"
let val = @m.xota.xm1.msky130_fd_pr__nfet_01v8[vth]
echo "@m.xota.m1[vth] = $&val"
let val = @m.xota.xm1.msky130_fd_pr__nfet_01v8[vds]
echo "@m.xota.m1[vds] = $&val"
let val = @m.xota.xm1.msky130_fd_pr__nfet_01v8[vdsat]
echo "@m.xota.m1[vdsat] = $&val"
let val = @m.xota.xm1.msky130_fd_pr__nfet_01v8[id]
echo "@m.xota.m1[id] = $&val"
let val = @m.xota.xm1.msky130_fd_pr__nfet_01v8[gm]
echo "@m.xota.m1[gm] = $&val"
let val = @m.xota.xm1.msky130_fd_pr__nfet_01v8[gds]
echo "@m.xota.m1[gds] = $&val"

* M2 — input- (NMOS, on v_s1 side)
let val = @m.xota.xm2.msky130_fd_pr__nfet_01v8[vgs]
echo "@m.xota.m2[vgs] = $&val"
let val = @m.xota.xm2.msky130_fd_pr__nfet_01v8[vth]
echo "@m.xota.m2[vth] = $&val"
let val = @m.xota.xm2.msky130_fd_pr__nfet_01v8[vds]
echo "@m.xota.m2[vds] = $&val"
let val = @m.xota.xm2.msky130_fd_pr__nfet_01v8[vdsat]
echo "@m.xota.m2[vdsat] = $&val"
let val = @m.xota.xm2.msky130_fd_pr__nfet_01v8[id]
echo "@m.xota.m2[id] = $&val"
let val = @m.xota.xm2.msky130_fd_pr__nfet_01v8[gm]
echo "@m.xota.m2[gm] = $&val"
let val = @m.xota.xm2.msky130_fd_pr__nfet_01v8[gds]
echo "@m.xota.m2[gds] = $&val"

* M3 — PMOS mirror diode
let val = @m.xota.xm3.msky130_fd_pr__pfet_01v8[vgs]
echo "@m.xota.m3[vgs] = $&val"
let val = @m.xota.xm3.msky130_fd_pr__pfet_01v8[vth]
echo "@m.xota.m3[vth] = $&val"
let val = @m.xota.xm3.msky130_fd_pr__pfet_01v8[vds]
echo "@m.xota.m3[vds] = $&val"
let val = @m.xota.xm3.msky130_fd_pr__pfet_01v8[vdsat]
echo "@m.xota.m3[vdsat] = $&val"
let val = @m.xota.xm3.msky130_fd_pr__pfet_01v8[id]
echo "@m.xota.m3[id] = $&val"
let val = @m.xota.xm3.msky130_fd_pr__pfet_01v8[gm]
echo "@m.xota.m3[gm] = $&val"
let val = @m.xota.xm3.msky130_fd_pr__pfet_01v8[gds]
echo "@m.xota.m3[gds] = $&val"

* M4 — PMOS mirror output
let val = @m.xota.xm4.msky130_fd_pr__pfet_01v8[vgs]
echo "@m.xota.m4[vgs] = $&val"
let val = @m.xota.xm4.msky130_fd_pr__pfet_01v8[vth]
echo "@m.xota.m4[vth] = $&val"
let val = @m.xota.xm4.msky130_fd_pr__pfet_01v8[vds]
echo "@m.xota.m4[vds] = $&val"
let val = @m.xota.xm4.msky130_fd_pr__pfet_01v8[vdsat]
echo "@m.xota.m4[vdsat] = $&val"
let val = @m.xota.xm4.msky130_fd_pr__pfet_01v8[id]
echo "@m.xota.m4[id] = $&val"
let val = @m.xota.xm4.msky130_fd_pr__pfet_01v8[gm]
echo "@m.xota.m4[gm] = $&val"
let val = @m.xota.xm4.msky130_fd_pr__pfet_01v8[gds]
echo "@m.xota.m4[gds] = $&val"

* M5 — Stage 2 CS (PMOS)
let val = @m.xota.xm5.msky130_fd_pr__pfet_01v8[vgs]
echo "@m.xota.m5[vgs] = $&val"
let val = @m.xota.xm5.msky130_fd_pr__pfet_01v8[vth]
echo "@m.xota.m5[vth] = $&val"
let val = @m.xota.xm5.msky130_fd_pr__pfet_01v8[vds]
echo "@m.xota.m5[vds] = $&val"
let val = @m.xota.xm5.msky130_fd_pr__pfet_01v8[vdsat]
echo "@m.xota.m5[vdsat] = $&val"
let val = @m.xota.xm5.msky130_fd_pr__pfet_01v8[id]
echo "@m.xota.m5[id] = $&val"
let val = @m.xota.xm5.msky130_fd_pr__pfet_01v8[gm]
echo "@m.xota.m5[gm] = $&val"
let val = @m.xota.xm5.msky130_fd_pr__pfet_01v8[gds]
echo "@m.xota.m5[gds] = $&val"

* M7 — Stage 2 sink (NMOS)
let val = @m.xota.xm7.msky130_fd_pr__nfet_01v8[vgs]
echo "@m.xota.m7[vgs] = $&val"
let val = @m.xota.xm7.msky130_fd_pr__nfet_01v8[vth]
echo "@m.xota.m7[vth] = $&val"
let val = @m.xota.xm7.msky130_fd_pr__nfet_01v8[vds]
echo "@m.xota.m7[vds] = $&val"
let val = @m.xota.xm7.msky130_fd_pr__nfet_01v8[vdsat]
echo "@m.xota.m7[vdsat] = $&val"
let val = @m.xota.xm7.msky130_fd_pr__nfet_01v8[id]
echo "@m.xota.m7[id] = $&val"
let val = @m.xota.xm7.msky130_fd_pr__nfet_01v8[gm]
echo "@m.xota.m7[gm] = $&val"
let val = @m.xota.xm7.msky130_fd_pr__nfet_01v8[gds]
echo "@m.xota.m7[gds] = $&val"

* M11 — Tail (NMOS)
let val = @m.xota.xm11.msky130_fd_pr__nfet_01v8[vgs]
echo "@m.xota.m11[vgs] = $&val"
let val = @m.xota.xm11.msky130_fd_pr__nfet_01v8[vth]
echo "@m.xota.m11[vth] = $&val"
let val = @m.xota.xm11.msky130_fd_pr__nfet_01v8[vds]
echo "@m.xota.m11[vds] = $&val"
let val = @m.xota.xm11.msky130_fd_pr__nfet_01v8[vdsat]
echo "@m.xota.m11[vdsat] = $&val"
let val = @m.xota.xm11.msky130_fd_pr__nfet_01v8[id]
echo "@m.xota.m11[id] = $&val"
let val = @m.xota.xm11.msky130_fd_pr__nfet_01v8[gm]
echo "@m.xota.m11[gm] = $&val"
let val = @m.xota.xm11.msky130_fd_pr__nfet_01v8[gds]
echo "@m.xota.m11[gds] = $&val"

* Key node voltages
echo "v(out) = $&v(out)"
echo "v(xota.v_s1) = $&v(xota.v_s1)"
echo "v(vbn) = $&v(vbn)"
echo "i_supply = $&@m.xota.xm11.msky130_fd_pr__nfet_01v8[id]"

quit
.endc
.end

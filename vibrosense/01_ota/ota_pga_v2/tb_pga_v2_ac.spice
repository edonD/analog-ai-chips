* TB: PGA OTA v2 AC Open-Loop Analysis
* Loop-breaking inductor technique
.option scale=1e-6
.lib "sky130_minimal_v2.lib.spice" tt
.include "ota_pga_v2.spice"

.param vdd_val = 1.8
.param vcm_val = 0.9

Vdd vdd 0 dc {vdd_val}

* Bias voltages (ideal sources)
Vbn  vbn  0 dc 0.65
Vbcn vbcn 0 dc 0.88
Vbp  vbp  0 dc 0.73
Vbcp vbcp 0 dc 0.475

* AC stimulus on non-inverting input (inn)
* inp is inverting (inp↑→out↓), inn is non-inverting (inn↑→out↑)
Vinn inn 0 dc {vcm_val} ac 1

* Loop-breaking: L from out to inp (inverting), Cdc holds inp DC
Lbreak out inp 1G
Cdc inp 0 1

* OTA
Xota vdd 0 inp inn out vbn vbcn vbp vbcp ota_pga_v2
CL out 0 10p

.ac dec 100 0.1 100Meg

.control
run

* Peak gain
meas ac gain_peak_raw MAX vdb(out)

* Gain at specific frequencies
meas ac g1_raw FIND vdb(out) AT=1
meas ac g10_raw FIND vdb(out) AT=10
meas ac g100_raw FIND vdb(out) AT=100

* UGB and phase at UGB
meas ac ugb_raw WHEN vdb(out)=0 FALL=1
meas ac phase_ugb_rad FIND vp(out) WHEN vdb(out)=0 FALL=1

* Convert radians to degrees
let phase_ugb_deg = phase_ugb_rad * 180 / 3.14159265359

echo "gain_peak = $&gain_peak_raw"
echo "g1 = $&g1_raw"
echo "g10 = $&g10_raw"
echo "g100 = $&g100_raw"
echo "ugb = $&ugb_raw"
echo "phase_ugb = $&phase_ugb_deg"

quit
.endc
.end

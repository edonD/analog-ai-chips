* VibroSense PGA OTA v2 — Two-Stage Miller Compensated OTA
* SKY130A Process — 477 kHz UGB target at 10 pF load
* Replaces folded-cascode v1 (67.5 kHz) for PGA closed-loop BW
*
* Topology: NMOS diff pair + PMOS mirror (stage 1)
*           PMOS CS + NMOS sink (stage 2)
*           Miller Cc with nulling Rz
*
* Pin-compatible 9-pin interface with ota_pga v1:
*   vdd gnd inp inn out vbn vbcn vbp vbcp
*   vbcn, vbp, vbcp declared but unconnected inside
*
* All dimensions in microns — requires .option scale=1e-6 in testbench
* Compensation uses ideal R and C (not affected by scale)

** Parameterized device sizes (microns, used with .option scale=1e-6)
.param W1=5     L1=14       $ Input pair M1/M2
.param W3=2     L3=2        $ PMOS mirror M3/M4
.param W5=5     L5=1        $ Stage 2 CS M5
.param W7=5.5   L7=2        $ Stage 2 sink M7 (sized for actual SKY130 Vth~0.55)
.param W11=11.4 L11=14      $ Tail M11
.param Cc_val=3.5p          $ Miller cap (absolute, not affected by scale)
.param Rz_val=30k           $ Nulling resistor (~1.5/gm5, pushes zero into LHP)
.param Rvdd_val=10k         $ VDD supply filter R for PSRR
.param Cvdd_val=100n        $ VDD supply filter C (with Rvdd: fc=159Hz)

.subckt ota_pga_v2 vdd gnd inp inn out vbn vbcn vbp vbcp

** ================================================================
** STAGE 1: NMOS differential pair + PMOS current mirror active load
** ================================================================

** Tail current source — ~1.5 uA at vbn from bias generator
XM11  otail  vbn    gnd  gnd  sky130_fd_pr__nfet_01v8  w={W11}  l={L11}

** NMOS differential pair
** M1 on diode side (v_mir), M2 on output side (v_s1)
XM1   v_mir  inp    otail gnd  sky130_fd_pr__nfet_01v8  w={W1}   l={L1}
XM2   v_s1   inn    otail gnd  sky130_fd_pr__nfet_01v8  w={W1}   l={L1}

** Internal VDD rail with RC filter for PSRR improvement
** fc = 1/(2pi*Rvdd*Cvdd) = 159 Hz, drops 5.5mV at 5.5uA
Rvdd  vdd  vdd_int  {Rvdd_val}
Cvdd  vdd_int  gnd  {Cvdd_val}

** PMOS current mirror — self-biased (diode M3 on v_mir, driven M4 on v_s1)
** Single-ended output at M4 drain = v_s1
XM3   v_mir  v_mir  vdd_int  vdd_int  sky130_fd_pr__pfet_01v8   w={W3}   l={L3}
XM4   v_s1   v_mir  vdd_int  vdd_int  sky130_fd_pr__pfet_01v8   w={W3}   l={L3}

** ================================================================
** MILLER COMPENSATION: Rz in series with Cc from v_s1 to out
** Ideal R and C — not affected by .option scale
** ================================================================

** Nulling resistor
Rz    v_s1  rz_mid  {Rz_val}

** Miller compensation cap
Cc    rz_mid  out  {Cc_val}

** ================================================================
** STAGE 2: PMOS common-source amplifier
** ================================================================

** PMOS CS — gate = v_s1, source = decoupled VDD
XM5   out  v_s1  vdd_int  vdd_int  sky130_fd_pr__pfet_01v8      w={W5}   l={L5}

** NMOS current sink — gate = vbn (same bias as tail)
XM7   out  vbn   gnd  gnd  sky130_fd_pr__nfet_01v8      w={W7}   l={L7}

.ends ota_pga_v2

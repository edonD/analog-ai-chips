* TB: PGA OTA v2 CMRR — Common-Mode Rejection Ratio
.option scale=1e-6
.lib "sky130_minimal_v2.lib.spice" tt
.include "ota_pga_v2.spice"

Vdd vdd 0 dc 1.8
Vbn  vbn  0 dc 0.65
Vbcn vbcn 0 dc 0.88
Vbp  vbp  0 dc 0.73
Vbcp vbcp 0 dc 0.475

* Both inputs tied together — pure common-mode stimulus
Vcm inp 0 dc 0.9 ac 1
Vcm_n inn 0 dc 0.9 ac 1

Xota vdd 0 inp inn out vbn vbcn vbp vbcp ota_pga_v2
CL out 0 10p

.nodeset v(out)=0.9

.ac dec 100 0.1 100Meg

.control
run

* Common-mode gain at DC (1Hz proxy)
meas ac acm_dc FIND vdb(out) AT=1

* Differential gain estimate (~88 dB DC)
let adm_dc = 85.0
let cmrr = adm_dc - acm_dc

echo "acm_dc = $&acm_dc"
echo "cmrr_dc = $&cmrr"

quit
.endc
.end

* Bias sweep to find optimal operating point
.lib "sky130_minimal.lib.spice" tt
.include "ota_foldcasc.spice"

.param vdd_val = 1.8

Vdd vdd 0 dc {vdd_val}
Vss vss 0 dc 0

* All ideal voltage sources for biases
Vbn  vbn  0 dc 0.58
Vbcn vbcn 0 dc 0.80
Vbp  vbp  0 dc 0.83
Vbcp vbcp 0 dc 0.70

* Inputs at common mode
Vinp vinp 0 dc 0.9
Vinn vinn 0 dc 0.9

Xota vinp vinn vout vdd vss vbn vbcn vbp vbcp ota_foldcasc
CL vout 0 10p

.op

.control
  * Sweep Vbp to find output at mid-rail
  let vbp_sweep = vector(21)
  let vout_sweep = vector(21)
  let im11_sweep = vector(21)

  let idx = 0
  foreach vbp_val 0.70 0.72 0.74 0.76 0.78 0.80 0.82 0.84 0.86 0.88 0.90 0.92 0.94 0.96 0.98 1.00 1.02 1.04 1.06 1.08 1.10
    alter Vbp dc = $vbp_val
    op
    let vbp_sweep[idx] = $vbp_val
    let vout_sweep[idx] = v(vout)
    let im11_sweep[idx] = @m.xota.m11[id]
    echo "Vbp=$vbp_val Vout=$&v(vout) M11_Id=$&@m.xota.m11[id] M3_Id=$&@m.xota.m3[id] M9_Id=$&@m.xota.m9[id]"
    let idx = idx + 1
  end

  quit
.endc

.end

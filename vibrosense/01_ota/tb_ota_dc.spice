* TB02: DC Sweep — Output swing measurement
.lib "sky130_minimal.lib.spice" tt
.include "ota_foldcasc.spice"

.param vdd_val = 1.8

Vdd vdd 0 dc {vdd_val}

* Bias voltages
Vbn  vbn  0 dc 0.65
Vbcn vbcn 0 dc 0.88
Vbp  vbp  0 dc 0.73
Vbcp vbcp 0 dc 0.475

* Unity-gain feedback: vout → vinn
Vinp vinp 0 dc 0.9
Xota vinp vout vout vdd 0 vbn vbcn vbp vbcp ota_foldcasc
CL vout 0 10p

.dc Vinp 0 1.8 0.001

.control
run
meas dc vout_max MAX v(vout)
meas dc vout_min MIN v(vout)

echo "vout_max = $&vout_max"
echo "vout_min = $&vout_min"
quit
.endc
.end

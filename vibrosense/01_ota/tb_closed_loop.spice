* Closed-loop bandwidth at PGA gain settings: 1x, 4x, 16x, 64x
* Uses resistive feedback: gain = 1 + R2/R1
.lib "sky130_minimal.lib.spice" tt
.include "ota_foldcasc.spice"

Vdd vdd 0 dc 1.8
Vbn  vbn  0 dc 0.65
Vbcn vbcn 0 dc 0.88
Vbp  vbp  0 dc 0.73
Vbcp vbcp 0 dc 0.475

Vinp vinp 0 dc 0.9 ac 1
Xota vinp vinn vout vdd 0 vbn vbcn vbp vbcp ota_foldcasc
CL vout 0 10p

* Feedback network: gain = 1 + R2/R1
* Use R1=100k as base, vary R2
.param r1_val = 100k
.param r2_val = 0

R1 vout vinn {r1_val}
R2 vinn vmid {r2_val}
Vmid vmid 0 dc 0.9

.ac dec 100 1 10Meg

.control
* Gain = 1x (unity gain: R2=0, direct feedback)
alter R2 = 1m
alter R1 = 1G
run
meas ac bw_1x WHEN vdb(vout)='-3' FALL=1
meas ac gain_dc_1x FIND vdb(vout) AT=10
echo "GAIN=1x: BW=$&bw_1x DC_gain=$&gain_dc_1x"
wrdata cl_1x vdb(vout)
reset

* Gain = 4x (R2=300k, R1=100k: 1+3=4)
alter R2 = 300k
alter R1 = 100k
run
meas ac bw_4x WHEN vdb(vout)='vdb(vout)[0]-3' CROSS=1
meas ac gain_dc_4x FIND vdb(vout) AT=10
echo "GAIN=4x: BW=$&bw_4x DC_gain=$&gain_dc_4x"
wrdata cl_4x vdb(vout)
reset

* Gain = 16x (R2=1.5M, R1=100k: 1+15=16)
alter R2 = 1500k
alter R1 = 100k
run
meas ac bw_16x WHEN vdb(vout)='vdb(vout)[0]-3' CROSS=1
meas ac gain_dc_16x FIND vdb(vout) AT=10
echo "GAIN=16x: BW=$&bw_16x DC_gain=$&gain_dc_16x"
wrdata cl_16x vdb(vout)
reset

* Gain = 64x (R2=6.3M, R1=100k: 1+63=64)
alter R2 = 6300k
alter R1 = 100k
run
meas ac bw_64x WHEN vdb(vout)='vdb(vout)[0]-3' CROSS=1
meas ac gain_dc_64x FIND vdb(vout) AT=10
echo "GAIN=64x: BW=$&bw_64x DC_gain=$&gain_dc_64x"
wrdata cl_64x vdb(vout)

quit
.endc
.end

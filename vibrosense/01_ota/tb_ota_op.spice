* TB07: Operating Point Verification
.lib "sky130_minimal.lib.spice" tt
.include "ota_foldcasc.spice"

.param vdd_val = 1.8
.param vcm_val = 0.9

Vdd vdd 0 dc {vdd_val}

* Bias voltages
Vbn  vbn  0 dc 0.59
Vbcn vbcn 0 dc 0.88
Vbp  vbp  0 dc 0.73
Vbcp vbcp 0 dc 0.475

* Symmetric open-loop with output stabilization
Vinp vinp 0 dc {vcm_val}
Vinn vinn 0 dc {vcm_val}

Xota vinp vinn vout vdd 0 vbn vbcn vbp vbcp ota_foldcasc
CL vout 0 10p
* DC stabilization for both cascode output nodes
Rbias1 vout vmid 1e6
Rbias2 xota.cas_p vmid 1e6
Vmid vmid 0 dc {vcm_val}

.nodeset v(vout)=0.9 v(xota.cas_p)=0.9

.op
.save all
.control
run

* Print all 13 devices in verifier format
let val = @m.xota.xm1.msky130_fd_pr__nfet_01v8[vgs]
echo "@m.xota.m1[vgs] = $&val"
let val = @m.xota.xm1.msky130_fd_pr__nfet_01v8[vth]
echo "@m.xota.m1[vth] = $&val"
let val = @m.xota.xm1.msky130_fd_pr__nfet_01v8[vds]
echo "@m.xota.m1[vds] = $&val"
let val = @m.xota.xm1.msky130_fd_pr__nfet_01v8[vdsat]
echo "@m.xota.m1[vdsat] = $&val"
let val = @m.xota.xm1.msky130_fd_pr__nfet_01v8[id]
echo "@m.xota.m1[id] = $&val"
let val = @m.xota.xm1.msky130_fd_pr__nfet_01v8[gm]
echo "@m.xota.m1[gm] = $&val"
let val = @m.xota.xm1.msky130_fd_pr__nfet_01v8[gds]
echo "@m.xota.m1[gds] = $&val"
let val = @m.xota.xm2.msky130_fd_pr__nfet_01v8[vgs]
echo "@m.xota.m2[vgs] = $&val"
let val = @m.xota.xm2.msky130_fd_pr__nfet_01v8[vth]
echo "@m.xota.m2[vth] = $&val"
let val = @m.xota.xm2.msky130_fd_pr__nfet_01v8[vds]
echo "@m.xota.m2[vds] = $&val"
let val = @m.xota.xm2.msky130_fd_pr__nfet_01v8[vdsat]
echo "@m.xota.m2[vdsat] = $&val"
let val = @m.xota.xm2.msky130_fd_pr__nfet_01v8[id]
echo "@m.xota.m2[id] = $&val"
let val = @m.xota.xm2.msky130_fd_pr__nfet_01v8[gm]
echo "@m.xota.m2[gm] = $&val"
let val = @m.xota.xm2.msky130_fd_pr__nfet_01v8[gds]
echo "@m.xota.m2[gds] = $&val"
let val = @m.xota.xm7.msky130_fd_pr__nfet_01v8[vgs]
echo "@m.xota.m7[vgs] = $&val"
let val = @m.xota.xm7.msky130_fd_pr__nfet_01v8[vth]
echo "@m.xota.m7[vth] = $&val"
let val = @m.xota.xm7.msky130_fd_pr__nfet_01v8[vds]
echo "@m.xota.m7[vds] = $&val"
let val = @m.xota.xm7.msky130_fd_pr__nfet_01v8[vdsat]
echo "@m.xota.m7[vdsat] = $&val"
let val = @m.xota.xm7.msky130_fd_pr__nfet_01v8[id]
echo "@m.xota.m7[id] = $&val"
let val = @m.xota.xm7.msky130_fd_pr__nfet_01v8[gm]
echo "@m.xota.m7[gm] = $&val"
let val = @m.xota.xm7.msky130_fd_pr__nfet_01v8[gds]
echo "@m.xota.m7[gds] = $&val"
let val = @m.xota.xm8.msky130_fd_pr__nfet_01v8[vgs]
echo "@m.xota.m8[vgs] = $&val"
let val = @m.xota.xm8.msky130_fd_pr__nfet_01v8[vth]
echo "@m.xota.m8[vth] = $&val"
let val = @m.xota.xm8.msky130_fd_pr__nfet_01v8[vds]
echo "@m.xota.m8[vds] = $&val"
let val = @m.xota.xm8.msky130_fd_pr__nfet_01v8[vdsat]
echo "@m.xota.m8[vdsat] = $&val"
let val = @m.xota.xm8.msky130_fd_pr__nfet_01v8[id]
echo "@m.xota.m8[id] = $&val"
let val = @m.xota.xm8.msky130_fd_pr__nfet_01v8[gm]
echo "@m.xota.m8[gm] = $&val"
let val = @m.xota.xm8.msky130_fd_pr__nfet_01v8[gds]
echo "@m.xota.m8[gds] = $&val"
let val = @m.xota.xm9.msky130_fd_pr__nfet_01v8[vgs]
echo "@m.xota.m9[vgs] = $&val"
let val = @m.xota.xm9.msky130_fd_pr__nfet_01v8[vth]
echo "@m.xota.m9[vth] = $&val"
let val = @m.xota.xm9.msky130_fd_pr__nfet_01v8[vds]
echo "@m.xota.m9[vds] = $&val"
let val = @m.xota.xm9.msky130_fd_pr__nfet_01v8[vdsat]
echo "@m.xota.m9[vdsat] = $&val"
let val = @m.xota.xm9.msky130_fd_pr__nfet_01v8[id]
echo "@m.xota.m9[id] = $&val"
let val = @m.xota.xm9.msky130_fd_pr__nfet_01v8[gm]
echo "@m.xota.m9[gm] = $&val"
let val = @m.xota.xm9.msky130_fd_pr__nfet_01v8[gds]
echo "@m.xota.m9[gds] = $&val"
let val = @m.xota.xm10.msky130_fd_pr__nfet_01v8[vgs]
echo "@m.xota.m10[vgs] = $&val"
let val = @m.xota.xm10.msky130_fd_pr__nfet_01v8[vth]
echo "@m.xota.m10[vth] = $&val"
let val = @m.xota.xm10.msky130_fd_pr__nfet_01v8[vds]
echo "@m.xota.m10[vds] = $&val"
let val = @m.xota.xm10.msky130_fd_pr__nfet_01v8[vdsat]
echo "@m.xota.m10[vdsat] = $&val"
let val = @m.xota.xm10.msky130_fd_pr__nfet_01v8[id]
echo "@m.xota.m10[id] = $&val"
let val = @m.xota.xm10.msky130_fd_pr__nfet_01v8[gm]
echo "@m.xota.m10[gm] = $&val"
let val = @m.xota.xm10.msky130_fd_pr__nfet_01v8[gds]
echo "@m.xota.m10[gds] = $&val"
let val = @m.xota.xm11.msky130_fd_pr__nfet_01v8[vgs]
echo "@m.xota.m11[vgs] = $&val"
let val = @m.xota.xm11.msky130_fd_pr__nfet_01v8[vth]
echo "@m.xota.m11[vth] = $&val"
let val = @m.xota.xm11.msky130_fd_pr__nfet_01v8[vds]
echo "@m.xota.m11[vds] = $&val"
let val = @m.xota.xm11.msky130_fd_pr__nfet_01v8[vdsat]
echo "@m.xota.m11[vdsat] = $&val"
let val = @m.xota.xm11.msky130_fd_pr__nfet_01v8[id]
echo "@m.xota.m11[id] = $&val"
let val = @m.xota.xm11.msky130_fd_pr__nfet_01v8[gm]
echo "@m.xota.m11[gm] = $&val"
let val = @m.xota.xm11.msky130_fd_pr__nfet_01v8[gds]
echo "@m.xota.m11[gds] = $&val"
let val = @m.xota.xm3.msky130_fd_pr__pfet_01v8[vgs]
echo "@m.xota.m3[vgs] = $&val"
let val = @m.xota.xm3.msky130_fd_pr__pfet_01v8[vth]
echo "@m.xota.m3[vth] = $&val"
let val = @m.xota.xm3.msky130_fd_pr__pfet_01v8[vds]
echo "@m.xota.m3[vds] = $&val"
let val = @m.xota.xm3.msky130_fd_pr__pfet_01v8[vdsat]
echo "@m.xota.m3[vdsat] = $&val"
let val = @m.xota.xm3.msky130_fd_pr__pfet_01v8[id]
echo "@m.xota.m3[id] = $&val"
let val = @m.xota.xm3.msky130_fd_pr__pfet_01v8[gm]
echo "@m.xota.m3[gm] = $&val"
let val = @m.xota.xm3.msky130_fd_pr__pfet_01v8[gds]
echo "@m.xota.m3[gds] = $&val"
let val = @m.xota.xm4.msky130_fd_pr__pfet_01v8[vgs]
echo "@m.xota.m4[vgs] = $&val"
let val = @m.xota.xm4.msky130_fd_pr__pfet_01v8[vth]
echo "@m.xota.m4[vth] = $&val"
let val = @m.xota.xm4.msky130_fd_pr__pfet_01v8[vds]
echo "@m.xota.m4[vds] = $&val"
let val = @m.xota.xm4.msky130_fd_pr__pfet_01v8[vdsat]
echo "@m.xota.m4[vdsat] = $&val"
let val = @m.xota.xm4.msky130_fd_pr__pfet_01v8[id]
echo "@m.xota.m4[id] = $&val"
let val = @m.xota.xm4.msky130_fd_pr__pfet_01v8[gm]
echo "@m.xota.m4[gm] = $&val"
let val = @m.xota.xm4.msky130_fd_pr__pfet_01v8[gds]
echo "@m.xota.m4[gds] = $&val"
let val = @m.xota.xm5.msky130_fd_pr__pfet_01v8[vgs]
echo "@m.xota.m5[vgs] = $&val"
let val = @m.xota.xm5.msky130_fd_pr__pfet_01v8[vth]
echo "@m.xota.m5[vth] = $&val"
let val = @m.xota.xm5.msky130_fd_pr__pfet_01v8[vds]
echo "@m.xota.m5[vds] = $&val"
let val = @m.xota.xm5.msky130_fd_pr__pfet_01v8[vdsat]
echo "@m.xota.m5[vdsat] = $&val"
let val = @m.xota.xm5.msky130_fd_pr__pfet_01v8[id]
echo "@m.xota.m5[id] = $&val"
let val = @m.xota.xm5.msky130_fd_pr__pfet_01v8[gm]
echo "@m.xota.m5[gm] = $&val"
let val = @m.xota.xm5.msky130_fd_pr__pfet_01v8[gds]
echo "@m.xota.m5[gds] = $&val"
let val = @m.xota.xm6.msky130_fd_pr__pfet_01v8[vgs]
echo "@m.xota.m6[vgs] = $&val"
let val = @m.xota.xm6.msky130_fd_pr__pfet_01v8[vth]
echo "@m.xota.m6[vth] = $&val"
let val = @m.xota.xm6.msky130_fd_pr__pfet_01v8[vds]
echo "@m.xota.m6[vds] = $&val"
let val = @m.xota.xm6.msky130_fd_pr__pfet_01v8[vdsat]
echo "@m.xota.m6[vdsat] = $&val"
let val = @m.xota.xm6.msky130_fd_pr__pfet_01v8[id]
echo "@m.xota.m6[id] = $&val"
let val = @m.xota.xm6.msky130_fd_pr__pfet_01v8[gm]
echo "@m.xota.m6[gm] = $&val"
let val = @m.xota.xm6.msky130_fd_pr__pfet_01v8[gds]
echo "@m.xota.m6[gds] = $&val"
let val = @m.xota.xm12.msky130_fd_pr__pfet_01v8[vgs]
echo "@m.xota.m12[vgs] = $&val"
let val = @m.xota.xm12.msky130_fd_pr__pfet_01v8[vth]
echo "@m.xota.m12[vth] = $&val"
let val = @m.xota.xm12.msky130_fd_pr__pfet_01v8[vds]
echo "@m.xota.m12[vds] = $&val"
let val = @m.xota.xm12.msky130_fd_pr__pfet_01v8[vdsat]
echo "@m.xota.m12[vdsat] = $&val"
let val = @m.xota.xm12.msky130_fd_pr__pfet_01v8[id]
echo "@m.xota.m12[id] = $&val"
let val = @m.xota.xm12.msky130_fd_pr__pfet_01v8[gm]
echo "@m.xota.m12[gm] = $&val"
let val = @m.xota.xm12.msky130_fd_pr__pfet_01v8[gds]
echo "@m.xota.m12[gds] = $&val"
let val = @m.xota.xm13.msky130_fd_pr__pfet_01v8[vgs]
echo "@m.xota.m13[vgs] = $&val"
let val = @m.xota.xm13.msky130_fd_pr__pfet_01v8[vth]
echo "@m.xota.m13[vth] = $&val"
let val = @m.xota.xm13.msky130_fd_pr__pfet_01v8[vds]
echo "@m.xota.m13[vds] = $&val"
let val = @m.xota.xm13.msky130_fd_pr__pfet_01v8[vdsat]
echo "@m.xota.m13[vdsat] = $&val"
let val = @m.xota.xm13.msky130_fd_pr__pfet_01v8[id]
echo "@m.xota.m13[id] = $&val"
let val = @m.xota.xm13.msky130_fd_pr__pfet_01v8[gm]
echo "@m.xota.m13[gm] = $&val"
let val = @m.xota.xm13.msky130_fd_pr__pfet_01v8[gds]
echo "@m.xota.m13[gds] = $&val"
echo "v(vout) = $&v(vout)"
echo "-i(vdd) = $&-i(vdd)"
quit
.endc
.end

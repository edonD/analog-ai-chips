* ============================================================
* VibroSense Folded-Cascode OTA — SKY130A
* ============================================================
* Subcircuit: ota_foldcasc
* Uses raw BSIM4 model names (M-prefix, no subcircuit wrapper)
* ============================================================

* Parameterized device sizes for reusability
.param W1  = 10u   L1  = 1.0u  nf1  = 2
.param W2  = 10u   L2  = 1.0u  nf2  = 2
.param W3  =  8u   L3  = 1.0u  nf3  = 2
.param W4  =  8u   L4  = 1.0u  nf4  = 2
.param W5  =  8u   L5  = 0.5u  nf5  = 2
.param W6  =  8u   L6  = 0.5u  nf6  = 2
.param W7  =  4u   L7  = 0.5u  nf7  = 2
.param W8  =  4u   L8  = 0.5u  nf8  = 2
.param W9  =  2u   L9  = 4.0u  nf9  = 1
.param W10 =  2u   L10 = 4.0u  nf10 = 1
.param W11 =  4u   L11 = 4.0u  nf11 = 1
.param W12 =  8u   L12 = 2.0u  nf12 = 1
.param W13 =  8u   L13 = 2.0u  nf13 = 1

.subckt ota_foldcasc vinp vinn vout vdd vss vbn vbcn vbp vbcp

* --- Input Differential Pair ---
M1 fold_p vinp tail vss sky130_fd_pr__nfet_01v8__model W={W1} L={L1} nf={nf1}
M2 vout   vinn tail vss sky130_fd_pr__nfet_01v8__model W={W2} L={L2} nf={nf2}

* --- Tail Current Source ---
M11 tail vbn vss vss sky130_fd_pr__nfet_01v8__model W={W11} L={L11} nf={nf11}

* --- PMOS Fold Transistors (current sources from VDD) ---
M3  mid_p vbp vdd vdd sky130_fd_pr__pfet_01v8__model W={W3} L={L3} nf={nf3}
M4  mid_n vbp vdd vdd sky130_fd_pr__pfet_01v8__model W={W4} L={L4} nf={nf4}

* --- PMOS Bias Mirror Transistors (parallel with M3/M4) ---
M12 mid_p vbp vdd vdd sky130_fd_pr__pfet_01v8__model W={W12} L={L12} nf={nf12}
M13 mid_n vbp vdd vdd sky130_fd_pr__pfet_01v8__model W={W13} L={L13} nf={nf13}

* --- PMOS Cascode Transistors ---
M5  fold_p vbcp mid_p vdd sky130_fd_pr__pfet_01v8__model W={W5} L={L5} nf={nf5}
M6  vout   vbcp mid_n vdd sky130_fd_pr__pfet_01v8__model W={W6} L={L6} nf={nf6}

* --- NMOS Cascode Transistors ---
M7  fold_p vbcn src_n7 vss sky130_fd_pr__nfet_01v8__model W={W7} L={L7} nf={nf7}
M8  vout   vbcn src_n8 vss sky130_fd_pr__nfet_01v8__model W={W8} L={L8} nf={nf8}

* --- NMOS Current Source Transistors ---
M9  src_n7 vbn vss vss sky130_fd_pr__nfet_01v8__model W={W9} L={L9} nf={nf9}
M10 src_n8 vbn vss vss sky130_fd_pr__nfet_01v8__model W={W10} L={L10} nf={nf10}

.ends ota_foldcasc

* VibroSense Folded-Cascode OTA — SKY130A v6
* Carefully balanced for Vov constraints at 500nA tail

.subckt ota_foldcasc vinp vinn vout vdd vss vbn vbcn vbp vbcp

* Input Pair (W=0.36u for Vov>50mV at 250nA)
XM1 fold_p vinp tail vss sky130_fd_pr__nfet_01v8 W=0.36u L=1u nf=1
XM2 fold_n vinn tail vss sky130_fd_pr__nfet_01v8 W=0.36u L=1u nf=1

* Tail (500nA)
XM11 tail vbn vss vss sky130_fd_pr__nfet_01v8 W=4u L=4u nf=1

* PMOS Fold (W=0.42u L=1u, ~494nA at Vov≈150mV)
XM3  fold_p vbp vdd vdd sky130_fd_pr__pfet_01v8 W=0.42u L=1u nf=1
XM4  fold_n vbp vdd vdd sky130_fd_pr__pfet_01v8 W=0.42u L=1u nf=1

* PMOS Bias Mirrors (very long L: ~25nA, still Vov>150mV)
XM12 fold_p vbp vdd vdd sky130_fd_pr__pfet_01v8 W=0.42u L=20u nf=1
XM13 fold_n vbp vdd vdd sky130_fd_pr__pfet_01v8 W=0.42u L=20u nf=1

* PMOS Cascode (W=0.42u L=2u, Vov>150mV at ~269nA)
XM5  cas_p vbcp fold_p vdd sky130_fd_pr__pfet_01v8 W=0.42u L=2u nf=1
XM6  vout  vbcp fold_n vdd sky130_fd_pr__pfet_01v8 W=0.42u L=2u nf=1

* NMOS Cascode (W=0.36u L=1u, Vov>50mV at ~269nA)
XM7  cas_p vbcn src7 vss sky130_fd_pr__nfet_01v8 W=0.36u L=1u nf=1
XM8  vout  vbcn src8 vss sky130_fd_pr__nfet_01v8 W=0.36u L=1u nf=1

* NMOS Current Sources (269nA, ratio 0.538 of M11)
XM9  src7 vbn vss vss sky130_fd_pr__nfet_01v8 W=2.15u L=4u nf=1
XM10 src8 vbn vss vss sky130_fd_pr__nfet_01v8 W=2.15u L=4u nf=1

.ends ota_foldcasc

* VibroSense PGA Folded-Cascode OTA — SKY130A
* High-current variant for ~50 kHz UGB at 10 pF
* Derived from ota_foldcasc v11 — same topology, same 9-pin interface
*
* Changes from filter OTA:
*   M11 W: 3.8u -> 11.4u (3x tail current at same Vbn)
*   M3/M4: 20 -> 50 instances (fold must exceed input + cascode)
*   M12/M13: W=0.42u (same as fold — preserves narrow-channel Vth)
*   M9/M10: W=2.15u -> 3.5u (higher cascode current for SR > 30 mV/us)
*
* Current balance: I_fold(~1275nA) = I_M1(~817nA) + I_cascode(~458nA)

.subckt ota_pga vinp vinn vout vdd vss vbn vbcn vbp vbcp

* Input Pair (W=5u L=14u for low 1/f noise)
XM1 fold_p vinp tail vss sky130_fd_pr__nfet_01v8 W=5u L=14u nf=1
XM2 fold_n vinn tail vss sky130_fd_pr__nfet_01v8 W=5u L=14u nf=1

* Tail (~1.6uA) — 3x width for 3x current at same Vbn
XM11 tail vbn vss vss sky130_fd_pr__nfet_01v8 W=11.4u L=14u nf=1

* PMOS Fold: 50 parallel instances of W=0.42u L=20u per branch
* (Narrow W critical for SKY130 PMOS Vth reduction — do NOT widen)
* Left branch (fold_p)
XM3a  fold_p vbp vdd vdd sky130_fd_pr__pfet_01v8 W=0.42u L=20u nf=1
XM3b  fold_p vbp vdd vdd sky130_fd_pr__pfet_01v8 W=0.42u L=20u nf=1
XM3c  fold_p vbp vdd vdd sky130_fd_pr__pfet_01v8 W=0.42u L=20u nf=1
XM3d  fold_p vbp vdd vdd sky130_fd_pr__pfet_01v8 W=0.42u L=20u nf=1
XM3e  fold_p vbp vdd vdd sky130_fd_pr__pfet_01v8 W=0.42u L=20u nf=1
XM3f  fold_p vbp vdd vdd sky130_fd_pr__pfet_01v8 W=0.42u L=20u nf=1
XM3g  fold_p vbp vdd vdd sky130_fd_pr__pfet_01v8 W=0.42u L=20u nf=1
XM3h  fold_p vbp vdd vdd sky130_fd_pr__pfet_01v8 W=0.42u L=20u nf=1
XM3i  fold_p vbp vdd vdd sky130_fd_pr__pfet_01v8 W=0.42u L=20u nf=1
XM3j  fold_p vbp vdd vdd sky130_fd_pr__pfet_01v8 W=0.42u L=20u nf=1
XM3k  fold_p vbp vdd vdd sky130_fd_pr__pfet_01v8 W=0.42u L=20u nf=1
XM3l  fold_p vbp vdd vdd sky130_fd_pr__pfet_01v8 W=0.42u L=20u nf=1
XM3m  fold_p vbp vdd vdd sky130_fd_pr__pfet_01v8 W=0.42u L=20u nf=1
XM3n  fold_p vbp vdd vdd sky130_fd_pr__pfet_01v8 W=0.42u L=20u nf=1
XM3o  fold_p vbp vdd vdd sky130_fd_pr__pfet_01v8 W=0.42u L=20u nf=1
XM3p  fold_p vbp vdd vdd sky130_fd_pr__pfet_01v8 W=0.42u L=20u nf=1
XM3q  fold_p vbp vdd vdd sky130_fd_pr__pfet_01v8 W=0.42u L=20u nf=1
XM3r  fold_p vbp vdd vdd sky130_fd_pr__pfet_01v8 W=0.42u L=20u nf=1
XM3s  fold_p vbp vdd vdd sky130_fd_pr__pfet_01v8 W=0.42u L=20u nf=1
XM3t  fold_p vbp vdd vdd sky130_fd_pr__pfet_01v8 W=0.42u L=20u nf=1
XM3u  fold_p vbp vdd vdd sky130_fd_pr__pfet_01v8 W=0.42u L=20u nf=1
XM3v  fold_p vbp vdd vdd sky130_fd_pr__pfet_01v8 W=0.42u L=20u nf=1
XM3w  fold_p vbp vdd vdd sky130_fd_pr__pfet_01v8 W=0.42u L=20u nf=1
XM3x  fold_p vbp vdd vdd sky130_fd_pr__pfet_01v8 W=0.42u L=20u nf=1
XM3y  fold_p vbp vdd vdd sky130_fd_pr__pfet_01v8 W=0.42u L=20u nf=1
XM3z  fold_p vbp vdd vdd sky130_fd_pr__pfet_01v8 W=0.42u L=20u nf=1
XM3aa fold_p vbp vdd vdd sky130_fd_pr__pfet_01v8 W=0.42u L=20u nf=1
XM3ab fold_p vbp vdd vdd sky130_fd_pr__pfet_01v8 W=0.42u L=20u nf=1
XM3ac fold_p vbp vdd vdd sky130_fd_pr__pfet_01v8 W=0.42u L=20u nf=1
XM3ad fold_p vbp vdd vdd sky130_fd_pr__pfet_01v8 W=0.42u L=20u nf=1
XM3ae fold_p vbp vdd vdd sky130_fd_pr__pfet_01v8 W=0.42u L=20u nf=1
XM3af fold_p vbp vdd vdd sky130_fd_pr__pfet_01v8 W=0.42u L=20u nf=1
XM3ag fold_p vbp vdd vdd sky130_fd_pr__pfet_01v8 W=0.42u L=20u nf=1
XM3ah fold_p vbp vdd vdd sky130_fd_pr__pfet_01v8 W=0.42u L=20u nf=1
XM3ai fold_p vbp vdd vdd sky130_fd_pr__pfet_01v8 W=0.42u L=20u nf=1
XM3aj fold_p vbp vdd vdd sky130_fd_pr__pfet_01v8 W=0.42u L=20u nf=1
XM3ak fold_p vbp vdd vdd sky130_fd_pr__pfet_01v8 W=0.42u L=20u nf=1
XM3al fold_p vbp vdd vdd sky130_fd_pr__pfet_01v8 W=0.42u L=20u nf=1
XM3am fold_p vbp vdd vdd sky130_fd_pr__pfet_01v8 W=0.42u L=20u nf=1
XM3an fold_p vbp vdd vdd sky130_fd_pr__pfet_01v8 W=0.42u L=20u nf=1
XM3ao fold_p vbp vdd vdd sky130_fd_pr__pfet_01v8 W=0.42u L=20u nf=1
XM3ap fold_p vbp vdd vdd sky130_fd_pr__pfet_01v8 W=0.42u L=20u nf=1
XM3aq fold_p vbp vdd vdd sky130_fd_pr__pfet_01v8 W=0.42u L=20u nf=1
XM3ar fold_p vbp vdd vdd sky130_fd_pr__pfet_01v8 W=0.42u L=20u nf=1
XM3as fold_p vbp vdd vdd sky130_fd_pr__pfet_01v8 W=0.42u L=20u nf=1
XM3at fold_p vbp vdd vdd sky130_fd_pr__pfet_01v8 W=0.42u L=20u nf=1
XM3au fold_p vbp vdd vdd sky130_fd_pr__pfet_01v8 W=0.42u L=20u nf=1
XM3av fold_p vbp vdd vdd sky130_fd_pr__pfet_01v8 W=0.42u L=20u nf=1
XM3aw fold_p vbp vdd vdd sky130_fd_pr__pfet_01v8 W=0.42u L=20u nf=1
XM3ax fold_p vbp vdd vdd sky130_fd_pr__pfet_01v8 W=0.42u L=20u nf=1
* Right branch (fold_n)
XM4a  fold_n vbp vdd vdd sky130_fd_pr__pfet_01v8 W=0.42u L=20u nf=1
XM4b  fold_n vbp vdd vdd sky130_fd_pr__pfet_01v8 W=0.42u L=20u nf=1
XM4c  fold_n vbp vdd vdd sky130_fd_pr__pfet_01v8 W=0.42u L=20u nf=1
XM4d  fold_n vbp vdd vdd sky130_fd_pr__pfet_01v8 W=0.42u L=20u nf=1
XM4e  fold_n vbp vdd vdd sky130_fd_pr__pfet_01v8 W=0.42u L=20u nf=1
XM4f  fold_n vbp vdd vdd sky130_fd_pr__pfet_01v8 W=0.42u L=20u nf=1
XM4g  fold_n vbp vdd vdd sky130_fd_pr__pfet_01v8 W=0.42u L=20u nf=1
XM4h  fold_n vbp vdd vdd sky130_fd_pr__pfet_01v8 W=0.42u L=20u nf=1
XM4i  fold_n vbp vdd vdd sky130_fd_pr__pfet_01v8 W=0.42u L=20u nf=1
XM4j  fold_n vbp vdd vdd sky130_fd_pr__pfet_01v8 W=0.42u L=20u nf=1
XM4k  fold_n vbp vdd vdd sky130_fd_pr__pfet_01v8 W=0.42u L=20u nf=1
XM4l  fold_n vbp vdd vdd sky130_fd_pr__pfet_01v8 W=0.42u L=20u nf=1
XM4m  fold_n vbp vdd vdd sky130_fd_pr__pfet_01v8 W=0.42u L=20u nf=1
XM4n  fold_n vbp vdd vdd sky130_fd_pr__pfet_01v8 W=0.42u L=20u nf=1
XM4o  fold_n vbp vdd vdd sky130_fd_pr__pfet_01v8 W=0.42u L=20u nf=1
XM4p  fold_n vbp vdd vdd sky130_fd_pr__pfet_01v8 W=0.42u L=20u nf=1
XM4q  fold_n vbp vdd vdd sky130_fd_pr__pfet_01v8 W=0.42u L=20u nf=1
XM4r  fold_n vbp vdd vdd sky130_fd_pr__pfet_01v8 W=0.42u L=20u nf=1
XM4s  fold_n vbp vdd vdd sky130_fd_pr__pfet_01v8 W=0.42u L=20u nf=1
XM4t  fold_n vbp vdd vdd sky130_fd_pr__pfet_01v8 W=0.42u L=20u nf=1
XM4u  fold_n vbp vdd vdd sky130_fd_pr__pfet_01v8 W=0.42u L=20u nf=1
XM4v  fold_n vbp vdd vdd sky130_fd_pr__pfet_01v8 W=0.42u L=20u nf=1
XM4w  fold_n vbp vdd vdd sky130_fd_pr__pfet_01v8 W=0.42u L=20u nf=1
XM4x  fold_n vbp vdd vdd sky130_fd_pr__pfet_01v8 W=0.42u L=20u nf=1
XM4y  fold_n vbp vdd vdd sky130_fd_pr__pfet_01v8 W=0.42u L=20u nf=1
XM4z  fold_n vbp vdd vdd sky130_fd_pr__pfet_01v8 W=0.42u L=20u nf=1
XM4aa fold_n vbp vdd vdd sky130_fd_pr__pfet_01v8 W=0.42u L=20u nf=1
XM4ab fold_n vbp vdd vdd sky130_fd_pr__pfet_01v8 W=0.42u L=20u nf=1
XM4ac fold_n vbp vdd vdd sky130_fd_pr__pfet_01v8 W=0.42u L=20u nf=1
XM4ad fold_n vbp vdd vdd sky130_fd_pr__pfet_01v8 W=0.42u L=20u nf=1
XM4ae fold_n vbp vdd vdd sky130_fd_pr__pfet_01v8 W=0.42u L=20u nf=1
XM4af fold_n vbp vdd vdd sky130_fd_pr__pfet_01v8 W=0.42u L=20u nf=1
XM4ag fold_n vbp vdd vdd sky130_fd_pr__pfet_01v8 W=0.42u L=20u nf=1
XM4ah fold_n vbp vdd vdd sky130_fd_pr__pfet_01v8 W=0.42u L=20u nf=1
XM4ai fold_n vbp vdd vdd sky130_fd_pr__pfet_01v8 W=0.42u L=20u nf=1
XM4aj fold_n vbp vdd vdd sky130_fd_pr__pfet_01v8 W=0.42u L=20u nf=1
XM4ak fold_n vbp vdd vdd sky130_fd_pr__pfet_01v8 W=0.42u L=20u nf=1
XM4al fold_n vbp vdd vdd sky130_fd_pr__pfet_01v8 W=0.42u L=20u nf=1
XM4am fold_n vbp vdd vdd sky130_fd_pr__pfet_01v8 W=0.42u L=20u nf=1
XM4an fold_n vbp vdd vdd sky130_fd_pr__pfet_01v8 W=0.42u L=20u nf=1
XM4ao fold_n vbp vdd vdd sky130_fd_pr__pfet_01v8 W=0.42u L=20u nf=1
XM4ap fold_n vbp vdd vdd sky130_fd_pr__pfet_01v8 W=0.42u L=20u nf=1
XM4aq fold_n vbp vdd vdd sky130_fd_pr__pfet_01v8 W=0.42u L=20u nf=1
XM4ar fold_n vbp vdd vdd sky130_fd_pr__pfet_01v8 W=0.42u L=20u nf=1
XM4as fold_n vbp vdd vdd sky130_fd_pr__pfet_01v8 W=0.42u L=20u nf=1
XM4at fold_n vbp vdd vdd sky130_fd_pr__pfet_01v8 W=0.42u L=20u nf=1
XM4au fold_n vbp vdd vdd sky130_fd_pr__pfet_01v8 W=0.42u L=20u nf=1
XM4av fold_n vbp vdd vdd sky130_fd_pr__pfet_01v8 W=0.42u L=20u nf=1
XM4aw fold_n vbp vdd vdd sky130_fd_pr__pfet_01v8 W=0.42u L=20u nf=1
XM4ax fold_n vbp vdd vdd sky130_fd_pr__pfet_01v8 W=0.42u L=20u nf=1

* PMOS Bias Mirrors (W=0.42u same as fold — preserves narrow-channel Vth)
XM12 fold_p vbp vdd vdd sky130_fd_pr__pfet_01v8 W=0.42u L=20u nf=1
XM13 fold_n vbp vdd vdd sky130_fd_pr__pfet_01v8 W=0.42u L=20u nf=1

* PMOS Cascode (W=0.84u L=2u — widened to reduce Vsg, keeps fold PMOS in saturation)
XM5  cas_p vbcp fold_p vdd sky130_fd_pr__pfet_01v8 W=0.84u L=2u nf=1
XM6  vout  vbcp fold_n vdd sky130_fd_pr__pfet_01v8 W=0.84u L=2u nf=1

* NMOS Cascode (W=2u L=14u) — unchanged
XM7  cas_p vbcn src7 vss sky130_fd_pr__nfet_01v8 W=2u L=14u nf=1
XM8  vout  vbcn src8 vss sky130_fd_pr__nfet_01v8 W=2u L=14u nf=1

* NMOS Current Sources (W=3.5u L=14u — scaled from 2.15u for SR > 30 mV/us)
XM9  src7 vbn vss vss sky130_fd_pr__nfet_01v8 W=3.5u L=14u nf=1
XM10 src8 vbn vss vss sky130_fd_pr__nfet_01v8 W=3.5u L=14u nf=1

.ends ota_pga

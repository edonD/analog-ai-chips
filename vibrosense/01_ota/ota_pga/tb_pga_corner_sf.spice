* TB: PGA OTA AC Open-Loop Analysis - SF Corner
.lib "../sky130_minimal.lib.spice" sf
.include "ota_pga.spice"

.param vdd_val = 1.8
.param vcm_val = 0.9

Vdd vdd 0 dc {vdd_val}

Ibias_n vdd vbn dc 1500n
Xbias_n vbn vbn 0 0 sky130_fd_pr__nfet_01v8 W=11.4u L=14u nf=1
Vbcn_off vbcn vbn dc 0.23
Ibias_p vbp 0 dc 25n
Xbias_p vbp vbp vdd vdd sky130_fd_pr__pfet_01v8 W=0.42u L=20u nf=1
Vbcp_off vbp vbcp dc 0.255
Cbn vbn 0 1
Cbp vbp 0 1

Vinp vinp 0 dc {vcm_val} ac 1
Lbreak vout vinn 1G
Cdc vinn 0 1

Xota vinp vinn vout vdd 0 vbn vbcn vbp vbcp ota_pga
CL vout 0 10p

.ac dec 100 0.1 1G

.control
run
meas ac gain_peak_raw MAX vdb(vout)
meas ac g1_raw FIND vdb(vout) AT=1
meas ac g10_raw FIND vdb(vout) AT=10
meas ac g100_raw FIND vdb(vout) AT=100
meas ac ugb_raw WHEN vdb(vout)=0 FALL=1
meas ac phase_ugb_rad FIND vp(vout) WHEN vdb(vout)=0 FALL=1
let phase_ugb_deg = phase_ugb_rad * 180 / 3.14159265359
echo "gain_peak = $&gain_peak_raw"
echo "g1 = $&g1_raw"
echo "g10 = $&g10_raw"
echo "g100 = $&g100_raw"
echo "ugb = $&ugb_raw"
echo "phase_ugb = $&phase_ugb_deg"
quit
.endc
.end

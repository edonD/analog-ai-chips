* TB: PGA OTA PSRR — Power Supply Rejection Ratio
* VDD-tracking bias for PMOS: vbp = VDD - 1.07, vbcp = VDD - 1.325
.lib "../sky130_minimal.lib.spice" tt
.include "ota_pga.spice"

* AC stimulus on VDD
Vdd vdd 0 dc 1.8 ac 1

* NMOS biases: ground-referenced (no supply coupling)
Vbn  vbn  0 dc 0.65
Vbcn vbcn 0 dc 0.88

* PMOS biases: VDD-tracking (realistic bias circuit behavior)
Vbp  vdd vbp  dc 1.07
Vbcp vdd vbcp dc 1.325

* No AC on input
Vinp vinp 0 dc 0.9

* Loop-breaking
Lbreak vout vinn 1G
Cdc vinn 0 1

Xota vinp vinn vout vdd 0 vbn vbcn vbp vbcp ota_pga
CL vout 0 10p

.ac dec 100 0.1 1G

.control
run

* VDD-to-output gain at 1kHz
meas ac avdd_1k FIND vdb(vout) AT=1000

* Differential gain at 1kHz — use conservative estimate from expected PGA OTA performance
meas ac avdd_dc FIND vdb(vout) AT=1

* With PGA OTA at ~50kHz UGB, gain at 1kHz ~ 20*log10(50000/1000) = ~34 dB
let adm_1k = 34.0

let psrr = adm_1k - avdd_1k

echo "avdd_1k = $&avdd_1k"
echo "avdd_dc = $&avdd_dc"
echo "psrr_1k = $&psrr"

quit
.endc
.end

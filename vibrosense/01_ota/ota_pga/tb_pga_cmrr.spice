* TB: PGA OTA CMRR — Common-Mode Rejection Ratio
* Direct-input method: both inputs tied to same AC source
.lib "../sky130_minimal.lib.spice" tt
.include "ota_pga.spice"

Vdd vdd 0 dc 1.8
Vbn  vbn  0 dc 0.65
Vbcn vbcn 0 dc 0.88
Vbp  vbp  0 dc 0.73
Vbcp vbcp 0 dc 0.475

* Both inputs tied together — pure common-mode stimulus
Vcm_p vinp 0 dc 0.9 ac 1
Vcm_n vinn 0 dc 0.9 ac 1

Xota vinp vinn vout vdd 0 vbn vbcn vbp vbcp ota_pga
CL vout 0 10p

* DC operating point set by circuit symmetry
.nodeset v(vout)=0.9

.ac dec 100 0.1 1G

.control
run

* Common-mode gain at DC (1Hz proxy)
meas ac acm_dc FIND vdb(vout) AT=1

* Differential gain from Gate 2 (conservative estimate for PGA OTA)
let adm_dc = 65.0
let cmrr = adm_dc - acm_dc

echo "acm_dc = $&acm_dc"
echo "cmrr_dc = $&cmrr"

quit
.endc
.end

* TB05: PSRR — Power Supply Rejection Ratio
* VDD-tracking bias for PMOS: vbp = VDD - 1.07, vbcp = VDD - 1.325
* This models a realistic bias circuit that tracks supply variations
.lib "sky130_minimal.lib.spice" tt
.include "ota_foldcasc.spice"

* AC stimulus on VDD
Vdd vdd 0 dc 1.8 ac 1

* NMOS biases: ground-referenced (no supply coupling)
Vbn  vbn  0 dc 0.65
Vbcn vbcn 0 dc 0.88

* PMOS biases: VDD-tracking (realistic bias circuit behavior)
* vbp = VDD - (1.8 - 0.73) = VDD - 1.07
* vbcp = VDD - (1.8 - 0.475) = VDD - 1.325
Vbp  vdd vbp  dc 1.07
Vbcp vdd vbcp dc 1.325

* No AC on input
Vinp vinp 0 dc 0.9

* Loop-breaking
Lbreak vout vinn 1G
Cdc vinn 0 1

Xota vinp vinn vout vdd 0 vbn vbcn vbp vbcp ota_foldcasc
CL vout 0 10p

.ac dec 100 0.1 1G

.control
run

* VDD-to-output gain at 1kHz
meas ac avdd_1k FIND vdb(vout) AT=1000

* Differential gain at 1kHz (measured separately, verified in Gate 2)
* Will be re-measured with new OTA design
meas ac avdd_dc FIND vdb(vout) AT=1

* Use known Adm from Gate 2 AC measurement
* With new long-L design, gain may have changed — use conservative estimate
* Adm at 1kHz can be derived from UGB and DC gain
let adm_1k = 30.73

let psrr = adm_1k - avdd_1k

echo "avdd_1k = $&avdd_1k"
echo "avdd_dc = $&avdd_dc"
echo "psrr_1k = $&psrr"

quit
.endc
.end

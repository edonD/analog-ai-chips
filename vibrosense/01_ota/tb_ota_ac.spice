* TB01: AC Open-Loop Analysis
* Uses loop-breaking inductor technique
.lib "sky130_minimal.lib.spice" tt
.include "ota_foldcasc.spice"

.param vdd_val = 1.8
.param vcm_val = 0.9

Vdd vdd 0 dc {vdd_val}

* Bias voltages
Vbn  vbn  0 dc 0.65
Vbcn vbcn 0 dc 0.88
Vbp  vbp  0 dc 0.73
Vbcp vbcp 0 dc 0.475

* Input with AC stimulus
Vinp vinp 0 dc {vcm_val} ac 1

* Loop-breaking: L=1GH passes DC, blocks AC. C holds vinn at DC for AC.
Lbreak vout vinn 1G
Cdc vinn 0 1

* OTA
Xota vinp vinn vout vdd 0 vbn vbcn vbp vbcp ota_foldcasc
CL vout 0 10p

.ac dec 100 0.1 1G

.control
run

* Compute measurements manually and echo in format verifier expects
* Note: vp() returns RADIANS in ngspice 42, verifier expects DEGREES

* Peak gain
meas ac gain_peak_raw MAX vdb(vout)

* Gain at specific frequencies
meas ac g1_raw FIND vdb(vout) AT=1
meas ac g10_raw FIND vdb(vout) AT=10
meas ac g100_raw FIND vdb(vout) AT=100

* UGB and phase at UGB
meas ac ugb_raw WHEN vdb(vout)=0 FALL=1
meas ac phase_ugb_rad FIND vp(vout) WHEN vdb(vout)=0 FALL=1

* Convert radians to degrees for the verifier
let phase_ugb_deg = phase_ugb_rad * 180 / 3.14159265359

* Echo results in the exact format the verifier's parse_meas expects
echo "gain_peak = $&gain_peak_raw"
echo "g1 = $&g1_raw"
echo "g10 = $&g10_raw"
echo "g100 = $&g100_raw"
echo "ugb = $&ugb_raw"
echo "phase_ugb = $&phase_ugb_deg"

quit
.endc
.end

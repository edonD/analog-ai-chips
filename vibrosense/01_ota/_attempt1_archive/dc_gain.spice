.lib "sky130_minimal.lib.spice" tt
.include "ota_foldcasc.spice"

Vdd vdd 0 dc 1.8
Vss vss 0 dc 0
Mbn vbn vbn 0 0 sky130_fd_pr__nfet_01v8__model W=4u L=4u nf=1
Ibias vdd vbn dc 500n
Vbcn vbcn 0 dc 0.80
Mbp vbp vbp vdd vdd sky130_fd_pr__pfet_01v8__model W=8u L=1u nf=2
Ibp vbp 0 dc 500n
Vbcp vbcp 0 dc 0.70

* Unity-gain with 1-ohm feedback
Vinp vinp 0 dc 0.9
Rfb vout vinn 1

Xota vinp vinn vout vdd vss vbn vbcn vbp vbcp ota_foldcasc
CL vout 0 10p

* Sweep input around 0.9V with tiny steps
.dc Vinp 0.895 0.905 0.0001

.control
  run
  * Measure slope at center point (0.9V)
  meas dc v_out_low FIND v(vout) AT=0.8999
  meas dc v_out_high FIND v(vout) AT=0.9001
  let slope = (v_out_high - v_out_low) / 0.0002
  echo "dVout/dVin (closed-loop) = $&slope"
  * For unity-gain feedback: CL_gain = A/(1+A)
  * Slope ≈ A/(1+A), so A = slope/(1-slope)
  let A = slope / (1 - slope)
  let A_db = 20*log(abs(A))/log(10)
  echo "Open-loop gain A = $&A"
  echo "Open-loop gain A (dB) = $&A_db"
  quit
.endc
.end

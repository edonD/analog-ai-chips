* DC Sweep (Output Swing) - VibroSense OTA
.lib "sky130_minimal.lib.spice" tt
.include "ota_foldcasc.spice"

Vdd vdd 0 dc 1.8
Vss vss 0 dc 0
Mbn vbn vbn 0 0 sky130_fd_pr__nfet_01v8__model W=4u L=4u nf=1
Ibias vdd vbn dc 500n
Vbcn vbcn 0 dc 0.80
Mbp vbp vbp vdd vdd sky130_fd_pr__pfet_01v8__model W=8u L=1u nf=2
Ibp vbp 0 dc 500n
Vbcp vbcp 0 dc 0.70

* Unity-gain feedback: connect vout to vinn directly
Vinn vinn vout dc 0

* Sweep the non-inverting input
Vinp vinp 0 dc 0.9

Xota vinp vinn vout vdd vss vbn vbcn vbp vbcp ota_foldcasc
CL vout 0 10p

* Sweep Vinp from 0 to 1.8V in 1mV steps
.dc Vinp 0 1.8 1m

.control
  run

  * Measure output swing
  meas dc vout_max MAX v(vout)
  meas dc vout_min MIN v(vout)
  let swing = vout_max - vout_min

  echo ""
  echo "======================================================"
  echo "  DC Sweep Results (Unity-Gain, Vinp: 0 -> 1.8V)"
  echo "======================================================"
  echo "Vout max: $&vout_max V"
  echo "Vout min: $&vout_min V"
  echo "Output swing: $&swing V"
  echo "======================================================"

  wrdata dc_swing_data v(vout) v(vinp)
  quit
.endc
.end

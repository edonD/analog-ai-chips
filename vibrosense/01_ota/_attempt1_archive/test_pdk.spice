* Minimal PDK test — raw BSIM4 models
.lib "sky130_minimal.lib.spice" tt

Vdd vdd 0 dc 1.8
Vgs gate 0 dc 0.6
Vds drain 0 dc 0.9

M1 drain gate 0 0 sky130_fd_pr__nfet_01v8__model W=10u L=1u nf=2

.op

.control
  run
  print @m1[id] @m1[vgs] @m1[vth] @m1[vds] @m1[vdsat] @m1[gm]
  quit
.endc

.end

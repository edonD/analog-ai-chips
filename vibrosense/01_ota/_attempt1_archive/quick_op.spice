.lib "sky130_minimal.lib.spice" tt
.include "ota_foldcasc.spice"

Vdd vdd 0 dc 1.8
Vss vss 0 dc 0
Vbn  vbn  0 dc 0.58
Vbcn vbcn 0 dc 0.80
Vbp  vbp  0 dc 0.855
Vbcp vbcp 0 dc 0.65
Vinp vinp 0 dc 0.9
Vinn vinn 0 dc 0.9

Xota vinp vinn vout vdd vss vbn vbcn vbp vbcp ota_foldcasc
CL vout 0 10p

.op
.control
  run
  echo "Vout = $&v(vout)"
  echo "M1 Id=$&@m.xota.m1[id] Vds=$&@m.xota.m1[vds]"
  echo "M2 Id=$&@m.xota.m2[id] Vds=$&@m.xota.m2[vds]"
  echo "M4 Id=$&@m.xota.m4[id] Vds=$&@m.xota.m4[vds] Vdsat=$&@m.xota.m4[vdsat]"
  echo "M6 Id=$&@m.xota.m6[id] Vds=$&@m.xota.m6[vds] Vdsat=$&@m.xota.m6[vdsat]"
  echo "M8 Id=$&@m.xota.m8[id] Vds=$&@m.xota.m8[vds] Vdsat=$&@m.xota.m8[vdsat]"
  echo "M10 Id=$&@m.xota.m10[id] Vds=$&@m.xota.m10[vds] Vdsat=$&@m.xota.m10[vdsat]"
  echo "M11 Id=$&@m.xota.m11[id] Vds=$&@m.xota.m11[vds] Vdsat=$&@m.xota.m11[vdsat]"
  quit
.endc
.end

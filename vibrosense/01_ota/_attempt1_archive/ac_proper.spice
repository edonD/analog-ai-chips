.lib "sky130_minimal.lib.spice" tt
.include "ota_foldcasc.spice"

Vdd vdd 0 dc 1.8
Vss vss 0 dc 0
Mbn vbn vbn 0 0 sky130_fd_pr__nfet_01v8__model W=4u L=4u nf=1
Ibias vdd vbn dc 500n
Vbcn vbcn 0 dc 0.80
Mbp vbp vbp vdd vdd sky130_fd_pr__pfet_01v8__model W=8u L=1u nf=2
Ibp vbp 0 dc 500n
Vbcp vbcp 0 dc 0.70

Vcm cm 0 dc 0.9
Vac vinp cm dc 0 ac 1
Vinn vinn 0 dc 0.9

* Force output to 0.9V at DC, let AC signal develop
* Use voltage source at output — it's AC grounded (Vfix is DC only)
* Actually this won't work for AC — Vfix shorts AC to ground

* Different approach: use big resistor feedback + small cap to set DC
* while keeping AC open-loop
Rfb_dc vout vinn_dc 10T
Vinn_dc vinn_dc 0 dc 0.9

Xota vinp vinn vout vdd vss vbn vbcn vbp vbcp ota_foldcasc
CL vout 0 10p

.ac dec 100 0.001 100Meg

.control
  run
  meas ac gain_db MAX vdb(vout)
  meas ac ugb WHEN vdb(vout)=0 FALL=1
  meas ac phase_ugb FIND vp(vout) AT=ugb
  let pm = phase_ugb + 180

  echo "DC Gain: $&gain_db dB"
  echo "UGB: $&ugb Hz"
  echo "Phase at UGB: $&phase_ugb deg"
  echo "Phase Margin: $&pm deg"

  meas ac gain_1hz FIND vdb(vout) AT=1
  meas ac gain_100hz FIND vdb(vout) AT=100
  meas ac gain_1k FIND vdb(vout) AT=1000
  meas ac gain_10k FIND vdb(vout) AT=10000

  echo "Gain at 1Hz: $&gain_1hz dB"
  echo "Gain at 100Hz: $&gain_100hz dB"
  echo "Gain at 1kHz: $&gain_1k dB"
  echo "Gain at 10kHz: $&gain_10k dB"

  wrdata bode_data vdb(vout) vp(vout)
  quit
.endc
.end

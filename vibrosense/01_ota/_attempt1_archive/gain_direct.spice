.lib "sky130_minimal.lib.spice" tt
.include "ota_foldcasc.spice"

Vdd vdd 0 dc 1.8
Vss vss 0 dc 0
Mbn vbn vbn 0 0 sky130_fd_pr__nfet_01v8__model W=4u L=4u nf=1
Ibias vdd vbn dc 500n
Vbcn vbcn 0 dc 0.80
Mbp vbp vbp vdd vdd sky130_fd_pr__pfet_01v8__model W=8u L=1u nf=2
Ibp vbp 0 dc 500n
Vbcp vbcp 0 dc 0.70

* Fix output at 0.9V, sweep diff input
Vinn vinn 0 dc 0.9
Vinp vinp 0 dc 0.9

Xota vinp vinn vout vdd vss vbn vbcn vbp vbcp ota_foldcasc
Vfix vout 0 dc 0.9

* Tiny sweep of Vinp around 0.9V
.dc Vinp 0.8999 0.9001 0.00001

.control
  run
  meas dc i_low FIND i(Vfix) AT=0.8999
  meas dc i_high FIND i(Vfix) AT=0.9001
  * Transconductance: Gm = di/dVinp
  let Gm = -(i_high - i_low) / 0.0002
  echo "Transconductance Gm = $&Gm A/V"

  * Gain = Gm * Rout = Gm * 75.8M
  let A = Gm * 75.8e6
  let A_db = 20*log(abs(A))/log(10)
  echo "Open-loop gain = $&A = $&A_db dB"

  * Also measure gm1 directly
  op
  echo "gm1=$&@m.xota.m1[gm] gm2=$&@m.xota.m2[gm]"
  echo "M1 Id=$&@m.xota.m1[id] M2 Id=$&@m.xota.m2[id]"
  quit
.endc
.end

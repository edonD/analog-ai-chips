.lib "sky130_minimal.lib.spice" tt
.include "ota_foldcasc.spice"

Vdd vdd 0 dc 1.8
Vss vss 0 dc 0
Mbn vbn vbn 0 0 sky130_fd_pr__nfet_01v8__model W=4u L=4u nf=1
Ibias vdd vbn dc 500n
Vbcn vbcn 0 dc 0.80
Mbp vbp vbp vdd vdd sky130_fd_pr__pfet_01v8__model W=8u L=1u nf=2
Ibp vbp 0 dc 500n
Vbcp vbcp 0 dc 0.70
Vinp vinp 0 dc 0.9
Lfb vout vinn 1T

Xota vinp vinn vout vdd vss vbn vbcn vbp vbcp ota_foldcasc
CL vout 0 10p

.op
.control
  run
  echo "=== All devices gds (output conductance) ==="
  echo "M1 gds=$&@m.xota.m1[gds]  M2 gds=$&@m.xota.m2[gds]"
  echo "M4 gds=$&@m.xota.m4[gds]  M6 gds=$&@m.xota.m6[gds]"
  echo "M8 gds=$&@m.xota.m8[gds]  M10 gds=$&@m.xota.m10[gds]"
  echo "M12 gds=$&@m.xota.m12[gds]  M13 gds=$&@m.xota.m13[gds]"
  echo ""
  echo "M2: ro = $&eval(1/@m.xota.m2[gds])"
  echo "Rout_p = gm6/gds6/gds4: gm6=$&@m.xota.m6[gm] gds6=$&@m.xota.m6[gds] gds4=$&@m.xota.m4[gds]"
  echo "Rout_n = gm8/gds8/gds10: gm8=$&@m.xota.m8[gm] gds8=$&@m.xota.m8[gds] gds10=$&@m.xota.m10[gds]"
  quit
.endc
.end

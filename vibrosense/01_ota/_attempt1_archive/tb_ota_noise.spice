* Noise Analysis - VibroSense OTA
.lib "sky130_minimal.lib.spice" tt
.include "ota_foldcasc.spice"

Vdd vdd 0 dc 1.8
Vss vss 0 dc 0
Mbn vbn vbn 0 0 sky130_fd_pr__nfet_01v8__model W=4u L=4u nf=1
Ibias vdd vbn dc 500n
Vbcn vbcn 0 dc 0.80
Mbp vbp vbp vdd vdd sky130_fd_pr__pfet_01v8__model W=8u L=1u nf=2
Ibp vbp 0 dc 500n
Vbcp vbcp 0 dc 0.70

* Input source for noise reference
Vcm cm 0 dc 0.9
Vac vinp cm dc 0 ac 1

* DC feedback
Lfb vout vinn 1T

Xota vinp vinn vout vdd vss vbn vbcn vbp vbcp ota_foldcasc
CL vout 0 10p

.noise V(vout) Vac dec 100 1 1Meg

.control
  run

  setplot noise1

  * Find values near 1kHz and 10kHz
  * The noise vectors are indexed by frequency
  let idx_1k = 300
  let idx_10k = 400

  echo ""
  echo "======================================================"
  echo "  Noise Analysis Results"
  echo "======================================================"

  * Print all noise spectrum data to file, then extract
  wrdata noise_data inoise_spectrum onoise_spectrum

  * Print first few values to verify
  print inoise_spectrum[299] inoise_spectrum[300] inoise_spectrum[301]
  print onoise_spectrum[299] onoise_spectrum[300] onoise_spectrum[301]

  echo "======================================================"
  quit
.endc
.end

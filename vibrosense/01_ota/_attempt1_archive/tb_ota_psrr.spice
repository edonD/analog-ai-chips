* PSRR Analysis - VibroSense OTA
* Power Supply Rejection Ratio = A_diff(dB) - A_vdd_to_out(dB)
.lib "sky130_minimal.lib.spice" tt
.include "ota_foldcasc.spice"

* VDD with AC perturbation for PSRR measurement
Vdd vdd 0 dc 1.8 ac 1
Vss vss 0 dc 0
Mbn vbn vbn 0 0 sky130_fd_pr__nfet_01v8__model W=4u L=4u nf=1
Ibias vdd vbn dc 500n
Vbcn vbcn 0 dc 0.80
Mbp vbp vbp vdd vdd sky130_fd_pr__pfet_01v8__model W=8u L=1u nf=2
Ibp vbp 0 dc 500n
Vbcp vbcp 0 dc 0.70

* Both inputs at Vcm for DC bias; no differential AC signal
Vinp vinp 0 dc 0.9
* Unity-gain feedback for DC operating point stability
Lfb vout vinn 1T

Xota vinp vinn vout vdd vss vbn vbcn vbp vbcp ota_foldcasc
CL vout 0 10p

* Sweep from 1Hz to 100MHz
.ac dec 100 1 100Meg

.control
  run

  * VDD-to-output gain in dB (this is what we want to reject)
  * Lower is better: PSRR = open-loop gain - this number
  let vdd_to_out_db = vdb(vout)

  * Spot values of VDD-to-output rejection
  meas ac rej_1hz   FIND vdb(vout) AT=1
  meas ac rej_1k    FIND vdb(vout) AT=1000
  meas ac rej_10k   FIND vdb(vout) AT=10000
  meas ac rej_100k  FIND vdb(vout) AT=100000
  meas ac rej_1meg  FIND vdb(vout) AT=1000000

  * Peak (worst-case) rejection
  meas ac rej_peak MAX vdb(vout)

  echo ""
  echo "======================================================"
  echo "  PSRR Analysis Results"
  echo "  (VDD AC perturbation -> V(vout); lower = better rejection)"
  echo "  PSRR(f) = A_diff(f) - Vout/Vdd(f) [dB]"
  echo "======================================================"
  echo "VDD-to-output gain (raw, not subtracted from diff gain):"
  echo "  1 Hz:    $&rej_1hz dB"
  echo "  1 kHz:   $&rej_1k dB"
  echo "  10 kHz:  $&rej_10k dB"
  echo "  100 kHz: $&rej_100k dB"
  echo "  1 MHz:   $&rej_1meg dB"
  echo ""
  echo "Peak (worst-case) VDD-to-output gain: $&rej_peak dB"
  echo ""
  echo "Note: PSRR = diff_gain_dB - vdd_to_output_gain_dB"
  echo "      Run tb_ota_ac.spice for diff gain, then subtract."
  echo "======================================================"

  wrdata psrr_data vdb(vout) vp(vout)
  quit
.endc
.end

* Minimal SKY130 library for VibroSense OTA design
* Self-contained model files — no external includes
* Model names: sky130_fd_pr__nfet_01v8__model, sky130_fd_pr__pfet_01v8__model

.lib tt
.include "models/sky130_fd_pr__nfet_01v8__tt_standalone.spice"
.include "models/sky130_fd_pr__pfet_01v8__tt_standalone.spice"
.endl tt

.lib ss
.include "models/sky130_fd_pr__nfet_01v8__ss_standalone.spice"
.include "models/sky130_fd_pr__pfet_01v8__ss_standalone.spice"
.endl ss

.lib ff
.include "models/sky130_fd_pr__nfet_01v8__ff_standalone.spice"
.include "models/sky130_fd_pr__pfet_01v8__ff_standalone.spice"
.endl ff

.lib sf
.include "models/sky130_fd_pr__nfet_01v8__sf_standalone.spice"
.include "models/sky130_fd_pr__pfet_01v8__sf_standalone.spice"
.endl sf

.lib fs
.include "models/sky130_fd_pr__nfet_01v8__fs_standalone.spice"
.include "models/sky130_fd_pr__pfet_01v8__fs_standalone.spice"
.endl fs

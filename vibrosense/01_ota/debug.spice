.lib "sky130_minimal.lib.spice" tt

Vdd vdd 0 dc 1.8
Vd d 0 dc 1.0
Vg g 0 dc 0.73

* M12: W=0.42u L=20u
XP1 d g vdd vdd sky130_fd_pr__pfet_01v8 W=0.42u L=20u nf=1

.op
.control
run
print @m.xp1.msky130_fd_pr__pfet_01v8[id]
print @m.xp1.msky130_fd_pr__pfet_01v8[vgs]
print @m.xp1.msky130_fd_pr__pfet_01v8[vth]
print @m.xp1.msky130_fd_pr__pfet_01v8[vdsat]

* Also try L=50u
alter @xp1[l] = 50u
op
print @m.xp1.msky130_fd_pr__pfet_01v8[id]
print @m.xp1.msky130_fd_pr__pfet_01v8[vth]
quit
.endc
.end

.lib "sky130_minimal.lib.spice" tt
.include "ota_opt.spice"
Vdd vdd 0 dc 1.8
Vss vss 0 dc 0
Mbn vbn vbn 0 0 sky130_fd_pr__nfet_01v8__model W=4u L=4u nf=1
Ibias vdd vbn dc 500n
Vbcn vbcn 0 dc 0.80
Mbp vbp vbp vdd vdd sky130_fd_pr__pfet_01v8__model W=8u L=2u nf=2
Ibp vbp 0 dc 500n
Vbcp vbcp 0 dc 0.70
Vinp vinp 0 dc 0.9
Lfb vout vinn 1T
Xota vinp vinn vout vdd vss vbn vbcn vbp vbcp ota_foldcasc
CL vout 0 10p
.tf v(vout) Vinp
.control
  run
  let cl = transfer_function
  let A = cl / (1 - cl)
  let A_db = 20*log(abs(A))/log(10)
  echo "A_db=$&A_db Vout=$&v(vout)"
  op
  echo "M2_gds=$&@m.xota.m2[gds] M4_Vds=$&@m.xota.m4[vds] M11_Id=$&@m.xota.m11[id]"
  quit
.endc
.end

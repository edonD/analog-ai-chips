* TB03: Transient Step Response — Slew rate
* Uses unity-gain with 100mV step per spec
.lib "sky130_minimal.lib.spice" tt
.include "ota_foldcasc.spice"

Vdd vdd 0 dc 1.8
Vbn  vbn  0 dc 0.59
Vbcn vbcn 0 dc 0.88
Vbp  vbp  0 dc 0.73
Vbcp vbcp 0 dc 0.475

* 100mV step at t=10us in unity-gain feedback
Vinp vinp 0 PULSE(0.9 1.0 10u 1n 1n 50u 100u)
Xota vinp vout vout vdd 0 vbn vbcn vbp vbcp ota_foldcasc
CL vout 0 10p

.tran 1n 100u

.control
run

* Measure initial slope (derivative method) as a proxy for SR
* The verifier needs t10 and t90 format
* Use derivative at 50% crossing
meas tran v_before FIND v(vout) AT=9.9u
meas tran v_after FIND v(vout) AT=50u

let step = v_after - v_before
let v_10 = v_before + 0.1 * step
let v_90 = v_before + 0.9 * step

meas tran t10_val WHEN v(vout)=$&v_10 RISE=1
meas tran t90_val WHEN v(vout)=$&v_90 RISE=1

echo "t10 = $&t10_val"
echo "t90 = $&t90_val"
quit
.endc
.end

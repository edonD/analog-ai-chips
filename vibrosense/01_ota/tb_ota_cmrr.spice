* TB06: CMRR — Common-Mode Rejection Ratio
* Both inputs see same AC signal (common-mode)
* CMRR = Adm_dB - Acm_dB at DC
.lib "sky130_minimal.lib.spice" tt
.include "ota_foldcasc.spice"

Vdd vdd 0 dc 1.8
Vbn  vbn  0 dc 0.59
Vbcn vbcn 0 dc 0.88
Vbp  vbp  0 dc 0.73
Vbcp vbcp 0 dc 0.475

* Common-mode AC source
Vcm vcm 0 dc 0.9 ac 1

* vinp directly connected to vcm
* vinn: DC from output via inductor, AC from vcm via coupling cap
Lbreak vout vinn 1G
Cac vcm vinn 1

Xota vcm vinn vout vdd 0 vbn vbcn vbp vbcp ota_foldcasc
CL vout 0 10p

.ac dec 100 0.1 1G

.control
run

* Common-mode gain at DC (1Hz proxy)
meas ac acm_dc FIND vdb(vout) AT=1

* Need differential gain for CMRR computation
* Run second sim with differential stimulus
alter Vcm ac = 0
* Create differential stimulus: need AC on vinp only
* But vinp is tied to vcm node. Use alter to change.
* Alternative: compute using known gain from Gate 2

* For now, use the DC gain measured in Gate 2 (~63.5 dB)
* This is the low-freq differential gain
let adm_dc = 63.5
let cmrr = adm_dc - acm_dc

echo "acm_dc = $&acm_dc"
echo "cmrr_dc = $&cmrr"

quit
.endc
.end

** tb_lvt2.spice — LVT PMOS with reduced W and tuned R1

.param mc_mm_switch=0
.param mc_pr_switch=0
.option scale=1e-6

.lib "/home/ubuntu/.volare/sky130A/libs.tech/combined/continuous/sky130.lib.spice" tt

** Config A: LVT PMOS W=0.5 L=4, R1=120k (same as before)
XM3a nba nba vdd vdd sky130_fd_pr__pfet_01v8_lvt w=0.5 l=4
XM4a outa nba vdd vdd sky130_fd_pr__pfet_01v8_lvt w=0.5 l=4
XM1a nba nba 0 0 sky130_fd_pr__nfet_01v8 w=2 l=4
XM2a outa nba srca 0 sky130_fd_pr__nfet_01v8 w=8 l=4
XR1a srca 0 0 sky130_fd_pr__res_xhigh_po w=0.35 l=21
XM7a irefa nba vdd vdd sky130_fd_pr__pfet_01v8_lvt w=0.5 l=4
VLa irefa 0 0.9

** Config B: LVT PMOS W=0.84 L=4, R1=120k
XM3b nbb nbb vdd vdd sky130_fd_pr__pfet_01v8_lvt w=0.84 l=4
XM4b outb nbb vdd vdd sky130_fd_pr__pfet_01v8_lvt w=0.84 l=4
XM1b nbb nbb 0 0 sky130_fd_pr__nfet_01v8 w=2 l=4
XM2b outb nbb srcb 0 sky130_fd_pr__nfet_01v8 w=8 l=4
XR1b srcb 0 0 sky130_fd_pr__res_xhigh_po w=0.35 l=21
XM7b irefb nbb vdd vdd sky130_fd_pr__pfet_01v8_lvt w=0.84 l=4
VLb irefb 0 0.9

** Config C: LVT PMOS W=0.42 L=8, R1=120k
XM3c nbc nbc vdd vdd sky130_fd_pr__pfet_01v8_lvt w=0.42 l=8
XM4c outc nbc vdd vdd sky130_fd_pr__pfet_01v8_lvt w=0.42 l=8
XM1c nbc nbc 0 0 sky130_fd_pr__nfet_01v8 w=2 l=4
XM2c outc nbc srcc 0 sky130_fd_pr__nfet_01v8 w=8 l=4
XR1c srcc 0 0 sky130_fd_pr__res_xhigh_po w=0.35 l=21
XM7c irefc nbc vdd vdd sky130_fd_pr__pfet_01v8_lvt w=0.42 l=8
VLc irefc 0 0.9

Vdd vdd 0 1.8
.nodeset v(nba)=0.62 v(nbb)=0.62 v(nbc)=0.62

.control
    foreach vdd_val 1.6 1.7 1.8 1.9 2.0
        alter Vdd = $vdd_val
        op
        echo "--- VDD = $vdd_val ---"
        let ia = abs(@m.xm7a.msky130_fd_pr__pfet_01v8_lvt[id]) * 1e9
        let m1a = @m.xm1a.msky130_fd_pr__nfet_01v8[id] * 1e9
        let m2a = @m.xm2a.msky130_fd_pr__nfet_01v8[id] * 1e9
        let m4a_vds = @m.xm4a.msky130_fd_pr__pfet_01v8_lvt[vds]
        let oda = abs(@m.xm3a.msky130_fd_pr__pfet_01v8_lvt[vgs]) - abs(@m.xm3a.msky130_fd_pr__pfet_01v8_lvt[vth])
        echo "A(W0.5/L4): Iref=$&ia nA  M1=$&m1a M2=$&m2a M4vds=$&m4a_vds od=$&oda nb=$&v(nba) on=$&v(outa)"

        let ib = abs(@m.xm7b.msky130_fd_pr__pfet_01v8_lvt[id]) * 1e9
        let m1b = @m.xm1b.msky130_fd_pr__nfet_01v8[id] * 1e9
        let m2b = @m.xm2b.msky130_fd_pr__nfet_01v8[id] * 1e9
        let m4b_vds = @m.xm4b.msky130_fd_pr__pfet_01v8_lvt[vds]
        let odb = abs(@m.xm3b.msky130_fd_pr__pfet_01v8_lvt[vgs]) - abs(@m.xm3b.msky130_fd_pr__pfet_01v8_lvt[vth])
        echo "B(W0.84/L4): Iref=$&ib nA  M1=$&m1b M2=$&m2b M4vds=$&m4b_vds od=$&odb nb=$&v(nbb) on=$&v(outb)"

        let ic = abs(@m.xm7c.msky130_fd_pr__pfet_01v8_lvt[id]) * 1e9
        let m1c = @m.xm1c.msky130_fd_pr__nfet_01v8[id] * 1e9
        let m2c = @m.xm2c.msky130_fd_pr__nfet_01v8[id] * 1e9
        let m4c_vds = @m.xm4c.msky130_fd_pr__pfet_01v8_lvt[vds]
        let odc = abs(@m.xm3c.msky130_fd_pr__pfet_01v8_lvt[vgs]) - abs(@m.xm3c.msky130_fd_pr__pfet_01v8_lvt[vth])
        echo "C(W0.42/L8): Iref=$&ic nA  M1=$&m1c M2=$&m2c M4vds=$&m4c_vds od=$&odc nb=$&v(nbc) on=$&v(outc)"
        echo ""
    end
.endc

.end

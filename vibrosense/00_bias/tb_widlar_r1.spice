** tb_widlar_r1.spice — Widlar variant: sweep R1 and check supply sensitivity
** Test different R1 values to find where regulation kicks in

.param mc_mm_switch=0
.param mc_pr_switch=0
.option scale=1e-6

.lib "/home/ubuntu/.volare/sky130A/libs.tech/combined/continuous/sky130.lib.spice" tt

** Config: Widlar, M1=4/8 (with R1), M2=1/8, LVT PMOS W=0.42 L=8
** R1 will be varied by using different resistor lengths

** R1a: l=10 (~75k)
XM3a nba nba vdd vdd sky130_fd_pr__pfet_01v8_lvt w=0.42 l=8
XM4a outa nba vdd vdd sky130_fd_pr__pfet_01v8_lvt w=0.42 l=8
XM1a nba nba srca 0 sky130_fd_pr__nfet_01v8 w=4 l=8
XR1a srca 0 0 sky130_fd_pr__res_xhigh_po w=0.35 l=10
XM2a outa nba 0 0 sky130_fd_pr__nfet_01v8 w=1 l=8
XM7a irefa nba vdd vdd sky130_fd_pr__pfet_01v8_lvt w=0.42 l=8
VLa irefa 0 0.9

** R1b: l=21 (~155k) — baseline
XM3b nbb nbb vdd vdd sky130_fd_pr__pfet_01v8_lvt w=0.42 l=8
XM4b outb nbb vdd vdd sky130_fd_pr__pfet_01v8_lvt w=0.42 l=8
XM1b nbb nbb srcb 0 sky130_fd_pr__nfet_01v8 w=4 l=8
XR1b srcb 0 0 sky130_fd_pr__res_xhigh_po w=0.35 l=21
XM2b outb nbb 0 0 sky130_fd_pr__nfet_01v8 w=1 l=8
XM7b irefb nbb vdd vdd sky130_fd_pr__pfet_01v8_lvt w=0.42 l=8
VLb irefb 0 0.9

** R1c: l=42 (~310k)
XM3c nbc nbc vdd vdd sky130_fd_pr__pfet_01v8_lvt w=0.42 l=8
XM4c outc nbc vdd vdd sky130_fd_pr__pfet_01v8_lvt w=0.42 l=8
XM1c nbc nbc srcc 0 sky130_fd_pr__nfet_01v8 w=4 l=8
XR1c srcc 0 0 sky130_fd_pr__res_xhigh_po w=0.35 l=42
XM2c outc nbc 0 0 sky130_fd_pr__nfet_01v8 w=1 l=8
XM7c irefc nbc vdd vdd sky130_fd_pr__pfet_01v8_lvt w=0.42 l=8
VLc irefc 0 0.9

** R1d: l=84 (~620k)
XM3d nbd nbd vdd vdd sky130_fd_pr__pfet_01v8_lvt w=0.42 l=8
XM4d outd nbd vdd vdd sky130_fd_pr__pfet_01v8_lvt w=0.42 l=8
XM1d nbd nbd srcd 0 sky130_fd_pr__nfet_01v8 w=4 l=8
XR1d srcd 0 0 sky130_fd_pr__res_xhigh_po w=0.35 l=84
XM2d outd nbd 0 0 sky130_fd_pr__nfet_01v8 w=1 l=8
XM7d irefd nbd vdd vdd sky130_fd_pr__pfet_01v8_lvt w=0.42 l=8
VLd irefd 0 0.9

** R1e: l=168 (~1.2M)
XM3e nbe nbe vdd vdd sky130_fd_pr__pfet_01v8_lvt w=0.42 l=8
XM4e oute nbe vdd vdd sky130_fd_pr__pfet_01v8_lvt w=0.42 l=8
XM1e nbe nbe srce 0 sky130_fd_pr__nfet_01v8 w=4 l=8
XR1e srce 0 0 sky130_fd_pr__res_xhigh_po w=0.35 l=168
XM2e oute nbe 0 0 sky130_fd_pr__nfet_01v8 w=1 l=8
XM7e irefe nbe vdd vdd sky130_fd_pr__pfet_01v8_lvt w=0.42 l=8
VLe irefe 0 0.9

Vdd vdd 0 1.8
.nodeset v(nba)=0.7 v(nbb)=0.7 v(nbc)=0.7 v(nbd)=0.7 v(nbe)=0.7

.control
    ** Sweep VDD for each R1 config
    echo "=== R1 sweep: VDD=1.6, 1.8, 2.0 for each R1 ==="
    echo ""

    ** Config A: R1~75k
    echo "--- R1a ~75k (l=10) ---"
    foreach vdd_val 1.6 1.8 2.0
        alter Vdd = $vdd_val
        op
        let iv = abs(@m.xm7a.msky130_fd_pr__pfet_01v8_lvt[id]) * 1e9
        let m2vds = @m.xm2a.msky130_fd_pr__nfet_01v8[vds]
        let i1 = abs(@m.xm1a.msky130_fd_pr__nfet_01v8[id]) * 1e9
        let i2 = abs(@m.xm2a.msky130_fd_pr__nfet_01v8[id]) * 1e9
        echo "VDD=$vdd_val Iref=$&iv M1=$&i1 M2=$&i2 M2_Vds=$&m2vds out_n=$&v(outa) src=$&v(srca)"
    end

    echo ""
    echo "--- R1b ~155k (l=21) ---"
    foreach vdd_val 1.6 1.8 2.0
        alter Vdd = $vdd_val
        op
        let iv = abs(@m.xm7b.msky130_fd_pr__pfet_01v8_lvt[id]) * 1e9
        let i1 = abs(@m.xm1b.msky130_fd_pr__nfet_01v8[id]) * 1e9
        let i2 = abs(@m.xm2b.msky130_fd_pr__nfet_01v8[id]) * 1e9
        echo "VDD=$vdd_val Iref=$&iv M1=$&i1 M2=$&i2 out_n=$&v(outb) src=$&v(srcb)"
    end

    echo ""
    echo "--- R1c ~310k (l=42) ---"
    foreach vdd_val 1.6 1.8 2.0
        alter Vdd = $vdd_val
        op
        let iv = abs(@m.xm7c.msky130_fd_pr__pfet_01v8_lvt[id]) * 1e9
        let i1 = abs(@m.xm1c.msky130_fd_pr__nfet_01v8[id]) * 1e9
        let i2 = abs(@m.xm2c.msky130_fd_pr__nfet_01v8[id]) * 1e9
        echo "VDD=$vdd_val Iref=$&iv M1=$&i1 M2=$&i2 out_n=$&v(outc) src=$&v(srcc)"
    end

    echo ""
    echo "--- R1d ~620k (l=84) ---"
    foreach vdd_val 1.6 1.8 2.0
        alter Vdd = $vdd_val
        op
        let iv = abs(@m.xm7d.msky130_fd_pr__pfet_01v8_lvt[id]) * 1e9
        let i1 = abs(@m.xm1d.msky130_fd_pr__nfet_01v8[id]) * 1e9
        let i2 = abs(@m.xm2d.msky130_fd_pr__nfet_01v8[id]) * 1e9
        echo "VDD=$vdd_val Iref=$&iv M1=$&i1 M2=$&i2 out_n=$&v(outd) src=$&v(srcd)"
    end

    echo ""
    echo "--- R1e ~1.2M (l=168) ---"
    foreach vdd_val 1.6 1.8 2.0
        alter Vdd = $vdd_val
        op
        let iv = abs(@m.xm7e.msky130_fd_pr__pfet_01v8_lvt[id]) * 1e9
        let i1 = abs(@m.xm1e.msky130_fd_pr__nfet_01v8[id]) * 1e9
        let i2 = abs(@m.xm2e.msky130_fd_pr__nfet_01v8[id]) * 1e9
        echo "VDD=$vdd_val Iref=$&iv M1=$&i1 M2=$&i2 out_n=$&v(oute) src=$&v(srce)"
    end

    ** Compute supply sensitivity for each
    echo ""
    echo "=== Supply Sensitivity Summary ==="
    alter Vdd = 1.6
    op
    let ia16 = abs(@m.xm7a.msky130_fd_pr__pfet_01v8_lvt[id])
    let ib16 = abs(@m.xm7b.msky130_fd_pr__pfet_01v8_lvt[id])
    let ic16 = abs(@m.xm7c.msky130_fd_pr__pfet_01v8_lvt[id])
    let id16 = abs(@m.xm7d.msky130_fd_pr__pfet_01v8_lvt[id])
    let ie16 = abs(@m.xm7e.msky130_fd_pr__pfet_01v8_lvt[id])
    alter Vdd = 1.8
    op
    let ia18 = abs(@m.xm7a.msky130_fd_pr__pfet_01v8_lvt[id])
    let ib18 = abs(@m.xm7b.msky130_fd_pr__pfet_01v8_lvt[id])
    let ic18 = abs(@m.xm7c.msky130_fd_pr__pfet_01v8_lvt[id])
    let id18 = abs(@m.xm7d.msky130_fd_pr__pfet_01v8_lvt[id])
    let ie18 = abs(@m.xm7e.msky130_fd_pr__pfet_01v8_lvt[id])
    alter Vdd = 2.0
    op
    let ia20 = abs(@m.xm7a.msky130_fd_pr__pfet_01v8_lvt[id])
    let ib20 = abs(@m.xm7b.msky130_fd_pr__pfet_01v8_lvt[id])
    let ic20 = abs(@m.xm7c.msky130_fd_pr__pfet_01v8_lvt[id])
    let id20 = abs(@m.xm7d.msky130_fd_pr__pfet_01v8_lvt[id])
    let ie20 = abs(@m.xm7e.msky130_fd_pr__pfet_01v8_lvt[id])

    let ssa = abs(ia20 - ia16) / ia18 / 0.4 * 100
    let ssb = abs(ib20 - ib16) / ib18 / 0.4 * 100
    let ssc = abs(ic20 - ic16) / ic18 / 0.4 * 100
    let ssd = abs(id20 - id16) / id18 / 0.4 * 100
    let sse = abs(ie20 - ie16) / ie18 / 0.4 * 100

    echo "R1~75k:  SS = $&ssa %/V"
    echo "R1~155k: SS = $&ssb %/V"
    echo "R1~310k: SS = $&ssc %/V"
    echo "R1~620k: SS = $&ssd %/V"
    echo "R1~1.2M: SS = $&sse %/V"
.endc

.end

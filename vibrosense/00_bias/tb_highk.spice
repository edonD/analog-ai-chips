** tb_highk.spice — Higher K ratios for better regulation
** Loop gain in subthreshold = ln(K), so higher K = better supply sensitivity

.param mc_mm_switch=0
.param mc_pr_switch=0
.option scale=1e-6

.lib "/home/ubuntu/.volare/sky130A/libs.tech/combined/continuous/sky130.lib.spice" tt

** Config A: K=9, R1=172k (I=86mV/172k=500nA), LVT PMOS W=0.42 L=8
** M1=2/4 (W/L=0.5), M2=18/4 (W/L=4.5), K=9
XM3a nba nba vdd vdd sky130_fd_pr__pfet_01v8_lvt w=0.42 l=8
XM4a outa nba vdd vdd sky130_fd_pr__pfet_01v8_lvt w=0.42 l=8
XM1a nba nba 0 0 sky130_fd_pr__nfet_01v8 w=2 l=4
XM2a outa nba srca 0 sky130_fd_pr__nfet_01v8 w=18 l=4
XR1a srca 0 0 sky130_fd_pr__res_xhigh_po w=0.35 l=30.1
XM7a irefa nba vdd vdd sky130_fd_pr__pfet_01v8_lvt w=0.42 l=8
VLa irefa 0 0.9

** Config B: K=16, R1=216k (I=108mV/216k=500nA), LVT PMOS W=0.42 L=8
** M1=2/4 (W/L=0.5), M2=32/4 (W/L=8), K=16
XM3b nbb nbb vdd vdd sky130_fd_pr__pfet_01v8_lvt w=0.42 l=8
XM4b outb nbb vdd vdd sky130_fd_pr__pfet_01v8_lvt w=0.42 l=8
XM1b nbb nbb 0 0 sky130_fd_pr__nfet_01v8 w=2 l=4
XM2b outb nbb srcb 0 sky130_fd_pr__nfet_01v8 w=32 l=4
XR1b srcb 0 0 sky130_fd_pr__res_xhigh_po w=0.35 l=37.8
XM7b irefb nbb vdd vdd sky130_fd_pr__pfet_01v8_lvt w=0.42 l=8
VLb irefb 0 0.9

** Config C: K=25, R1=252k (I=129mV/252k=512nA), LVT PMOS W=0.42 L=8
** M1=2/4, M2=50/4 (W/L=12.5), K=25
XM3c nbc nbc vdd vdd sky130_fd_pr__pfet_01v8_lvt w=0.42 l=8
XM4c outc nbc vdd vdd sky130_fd_pr__pfet_01v8_lvt w=0.42 l=8
XM1c nbc nbc 0 0 sky130_fd_pr__nfet_01v8 w=2 l=4
XM2c outc nbc srcc 0 sky130_fd_pr__nfet_01v8 w=50 l=4
XR1c srcc 0 0 sky130_fd_pr__res_xhigh_po w=0.35 l=44.1
XM7c irefc nbc vdd vdd sky130_fd_pr__pfet_01v8_lvt w=0.42 l=8
VLc irefc 0 0.9

** Config D: K=4 but longer L NMOS for higher ro, L=8
** M1=1/8 (W/L=0.125), M2=4/8 (W/L=0.5), K=4
** R1 same as original
XM3d nbd nbd vdd vdd sky130_fd_pr__pfet_01v8_lvt w=0.42 l=8
XM4d outd nbd vdd vdd sky130_fd_pr__pfet_01v8_lvt w=0.42 l=8
XM1d nbd nbd 0 0 sky130_fd_pr__nfet_01v8 w=1 l=8
XM2d outd nbd srcd 0 sky130_fd_pr__nfet_01v8 w=4 l=8
XR1d srcd 0 0 sky130_fd_pr__res_xhigh_po w=0.35 l=21
XM7d irefd nbd vdd vdd sky130_fd_pr__pfet_01v8_lvt w=0.42 l=8
VLd irefd 0 0.9

Vdd vdd 0 1.8
.nodeset v(nba)=0.6 v(nbb)=0.6 v(nbc)=0.6 v(nbd)=0.6

.control
    foreach vdd_val 1.6 1.7 1.8 1.9 2.0
        alter Vdd = $vdd_val
        op
        echo "--- VDD = $vdd_val ---"
        let ia = abs(@m.xm7a.msky130_fd_pr__pfet_01v8_lvt[id]) * 1e9
        let m1a = @m.xm1a.msky130_fd_pr__nfet_01v8[id] * 1e9
        let m2a = @m.xm2a.msky130_fd_pr__nfet_01v8[id] * 1e9
        let m4a = @m.xm4a.msky130_fd_pr__pfet_01v8_lvt[vds]
        echo "A(K9): Iref=$&ia  M1=$&m1a  M2=$&m2a  M4vds=$&m4a  on=$&v(outa)"

        let ib = abs(@m.xm7b.msky130_fd_pr__pfet_01v8_lvt[id]) * 1e9
        let m1b = @m.xm1b.msky130_fd_pr__nfet_01v8[id] * 1e9
        let m2b = @m.xm2b.msky130_fd_pr__nfet_01v8[id] * 1e9
        let m4b = @m.xm4b.msky130_fd_pr__pfet_01v8_lvt[vds]
        echo "B(K16): Iref=$&ib  M1=$&m1b  M2=$&m2b  M4vds=$&m4b  on=$&v(outb)"

        let ic = abs(@m.xm7c.msky130_fd_pr__pfet_01v8_lvt[id]) * 1e9
        let m1c = @m.xm1c.msky130_fd_pr__nfet_01v8[id] * 1e9
        let m2c = @m.xm2c.msky130_fd_pr__nfet_01v8[id] * 1e9
        let m4c = @m.xm4c.msky130_fd_pr__pfet_01v8_lvt[vds]
        echo "C(K25): Iref=$&ic  M1=$&m1c  M2=$&m2c  M4vds=$&m4c  on=$&v(outc)"

        let id_val = abs(@m.xm7d.msky130_fd_pr__pfet_01v8_lvt[id]) * 1e9
        let m1d = @m.xm1d.msky130_fd_pr__nfet_01v8[id] * 1e9
        let m2d = @m.xm2d.msky130_fd_pr__nfet_01v8[id] * 1e9
        let m4d = @m.xm4d.msky130_fd_pr__pfet_01v8_lvt[vds]
        echo "D(K4,L8): Iref=$&id_val  M1=$&m1d  M2=$&m2d  M4vds=$&m4d  on=$&v(outd)"
        echo ""
    end
.endc

.end

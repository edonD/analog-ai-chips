** tb_scaled.spice — Reduced core current + scaled output mirror
** Strategy: run core at ~100nA where PMOS can regulate even at VDD=1.6V
** Use 5:1 output mirror to get 500nA Iref

.param mc_mm_switch=0
.param mc_pr_switch=0
.option scale=1e-6

.lib "/home/ubuntu/.volare/sky130A/libs.tech/combined/continuous/sky130.lib.spice" tt

** === Config A: R1=540k (w=0.35 l=94.5), M7=5x ===
** R1 = 2000 * 94.5/0.35 = 540k
** Target core I = nVt*ln(4)/540k = 100nA
XM3a nba nba vdd vdd sky130_fd_pr__pfet_01v8 w=1.5 l=4
XM4a outa_n nba vdd vdd sky130_fd_pr__pfet_01v8 w=1.5 l=4
XM1a nba nba 0 0 sky130_fd_pr__nfet_01v8 w=2 l=4
XM2a outa_n nba srca 0 sky130_fd_pr__nfet_01v8 w=8 l=4
XR1a srca 0 0 sky130_fd_pr__res_xhigh_po w=0.35 l=94.5
XM7a irefa nba vdd vdd sky130_fd_pr__pfet_01v8 w=7.5 l=4
VLa irefa 0 0.9

** === Config B: R1=360k (w=0.35 l=63), M7=3.33x ===
** R1 = 2000 * 63/0.35 = 360k
** Target core I = 54mV/360k = 150nA
XM3b nbb nbb vdd vdd sky130_fd_pr__pfet_01v8 w=1.5 l=4
XM4b outb_n nbb vdd vdd sky130_fd_pr__pfet_01v8 w=1.5 l=4
XM1b nbb nbb 0 0 sky130_fd_pr__nfet_01v8 w=2 l=4
XM2b outb_n nbb srcb 0 sky130_fd_pr__nfet_01v8 w=8 l=4
XR1b srcb 0 0 sky130_fd_pr__res_xhigh_po w=0.35 l=63
XM7b irefb nbb vdd vdd sky130_fd_pr__pfet_01v8 w=5 l=4
VLb irefb 0 0.9

** === Config C: R1=270k (w=0.35 l=47.25), M7=2.5x ===
** R1 = 2000 * 47.25/0.35 = 270k
** Target core I = 54mV/270k = 200nA
XM3c nbc nbc vdd vdd sky130_fd_pr__pfet_01v8 w=1.5 l=4
XM4c outc_n nbc vdd vdd sky130_fd_pr__pfet_01v8 w=1.5 l=4
XM1c nbc nbc 0 0 sky130_fd_pr__nfet_01v8 w=2 l=4
XM2c outc_n nbc srcc 0 sky130_fd_pr__nfet_01v8 w=8 l=4
XR1c srcc 0 0 sky130_fd_pr__res_xhigh_po w=0.35 l=47.25
XM7c irefc nbc vdd vdd sky130_fd_pr__pfet_01v8 w=3.75 l=4
VLc irefc 0 0.9

Vdd vdd 0 1.8
.nodeset v(nba)=0.55 v(nbb)=0.55 v(nbc)=0.55

.control
    ** Test each config at VDD = 1.6, 1.8, 2.0
    foreach vdd_val 1.6 1.8 2.0
        alter Vdd = $vdd_val
        op
        echo "--- VDD = $vdd_val ---"

        let ia = abs(@m.xm7a.msky130_fd_pr__pfet_01v8[id]) * 1e9
        let m1a = @m.xm1a.msky130_fd_pr__nfet_01v8[id] * 1e9
        let m2a = @m.xm2a.msky130_fd_pr__nfet_01v8[id] * 1e9
        let m4a_vds = @m.xm4a.msky130_fd_pr__pfet_01v8[vds]
        echo "A (R1=540k 5x): Iref=$&ia nA  core_M1=$&m1a  core_M2=$&m2a  M4vds=$&m4a_vds  nbias=$&v(nba)  out_n=$&v(outa_n)"

        let ib = abs(@m.xm7b.msky130_fd_pr__pfet_01v8[id]) * 1e9
        let m1b = @m.xm1b.msky130_fd_pr__nfet_01v8[id] * 1e9
        let m2b = @m.xm2b.msky130_fd_pr__nfet_01v8[id] * 1e9
        let m4b_vds = @m.xm4b.msky130_fd_pr__pfet_01v8[vds]
        echo "B (R1=360k 3x): Iref=$&ib nA  core_M1=$&m1b  core_M2=$&m2b  M4vds=$&m4b_vds  nbias=$&v(nbb)  out_n=$&v(outb_n)"

        let ic = abs(@m.xm7c.msky130_fd_pr__pfet_01v8[id]) * 1e9
        let m1c = @m.xm1c.msky130_fd_pr__nfet_01v8[id] * 1e9
        let m2c = @m.xm2c.msky130_fd_pr__nfet_01v8[id] * 1e9
        let m4c_vds = @m.xm4c.msky130_fd_pr__pfet_01v8[vds]
        echo "C (R1=270k 2.5x): Iref=$&ic nA  core_M1=$&m1c  core_M2=$&m2c  M4vds=$&m4c_vds  nbias=$&v(nbc)  out_n=$&v(outc_n)"

        echo ""
    end
.endc

.end

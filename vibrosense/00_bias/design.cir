** VibroSense Block 00: Beta-Multiplier Self-Biased Current Reference
** SKY130A Process — design.cir
**
** All dimensions in microns. Use with:
**   .option scale=1e-6
**   .lib ".../combined/continuous/sky130.lib.spice" <corner>
**
** Design: OTA-regulated beta-multiplier with TC-compensated R1
** Swapped OTA forces V(out_n)=V(nbias) with correct negative feedback
** Dominant-pole compensation (5pF MIM cap on od1)
** RC-timed startup switch (vbias↔nbias) for guaranteed power-on

.subckt bias_generator vdd gnd iref_out

** ===== PMOS Current Mirror (gate = vbias from OTA) =====
XM3 nbias vbias vdd vdd sky130_fd_pr__pfet_01v8 w=4 l=4
XM4 out_n vbias vdd vdd sky130_fd_pr__pfet_01v8 w=4 l=4

** ===== NMOS Pair (K = W2/W1 = 4) =====
XM1 nbias nbias gnd gnd sky130_fd_pr__nfet_01v8 w=2 l=4
XM2 out_n nbias src_m2 gnd sky130_fd_pr__nfet_01v8 w=8 l=4

** ===== R1: TC-compensated resistor =====
** xhigh_po (TC~0) in series with iso_pw (TC~3460 ppm/C)
** Tuned ratio: max TC = 149 ppm/C across all 5 corners
XR1a src_m2 mid_r gnd sky130_fd_pr__res_xhigh_po w=0.35 l=7.09
XR1b mid_r gnd gnd sky130_fd_pr__res_iso_pw w=0.35 l=6.56

** ===== Swapped OTA: forces V(out_n) = V(nbias) =====
** Mo1 gate=out_n, Mo2 gate=nbias → correct negative feedback
** (Original polarity had positive feedback → transient instability)
XMo1 od1 out_n otail gnd sky130_fd_pr__nfet_01v8 w=1 l=4
XMo2 vbias nbias otail gnd sky130_fd_pr__nfet_01v8 w=1 l=4
** PMOS active load (current mirror)
XMo3 od1 od1 vdd vdd sky130_fd_pr__pfet_01v8 w=2 l=4
XMo4 vbias od1 vdd vdd sky130_fd_pr__pfet_01v8 w=2 l=4
** Tail current source
XMo5 otail nbias gnd gnd sky130_fd_pr__nfet_01v8 w=1 l=4

** ===== Dominant-Pole Compensation =====
** 5pF MIM cap on OTA first-stage output (od1→GND)
** Stabilizes the two-stage OTA + beta-multiplier loop
XC_comp od1 gnd gnd sky130_fd_pr__cap_mim_m3_1 w=50 l=50

** ===== Output Mirror (NMOS, mirrors M1 via nbias) =====
** NMOS mirror eliminates PMOS PDK parasitic TC contribution
** Matches M1 geometry (W=2 L=4) for 1:1 current copy
XM7 iref_out nbias gnd gnd sky130_fd_pr__nfet_01v8 w=2 l=4

** ===== Anti-Deadlock Leaker =====
** Subthreshold NMOS (gate=GND, Vgs=0) provides ~pA leakage
** Prevents permanent zero-current lock-up
XM6 vbias gnd gnd gnd sky130_fd_pr__nfet_01v8 w=0.5 l=0.5

** ===== RC Startup Circuit =====
** During VDD ramp: C_gs couples dVDD/dt → gs node goes high → XMsw ON
** XMsw shorts vbias to nbias → circuit starts near correct OP
** After VDD stable: gs decays through R_gs (τ≈25μs) → XMsw OFF
** At DC: gs=0, XMsw fully off, zero perturbation to operating point
XC_gs vdd gs gnd sky130_fd_pr__cap_mim_m3_1 w=25 l=50
XR_gs gs gnd gnd sky130_fd_pr__res_xhigh_po w=0.35 l=1360
XMsw vbias gs nbias gnd sky130_fd_pr__nfet_01v8 w=4 l=0.5

.ends bias_generator

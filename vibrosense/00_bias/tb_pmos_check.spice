** Check PMOS Vth at different W/L

.param mc_mm_switch=0
.param mc_pr_switch=0
.option scale=1e-6

.lib "/home/ubuntu/.volare/sky130A/libs.tech/combined/continuous/sky130.lib.spice" tt

** Test 1: W=4 L=4
XM1 d1 g1 vdd vdd sky130_fd_pr__pfet_01v8 w=4 l=4
Vd1 d1 0 0.9
Vg1 g1 0 0.9

** Test 2: W=8 L=1
XM2 d2 g2 vdd vdd sky130_fd_pr__pfet_01v8 w=8 l=1
Vd2 d2 0 0.9
Vg2 g2 0 0.9

** Test 3: W=4 L=1
XM3 d3 g3 vdd vdd sky130_fd_pr__pfet_01v8 w=4 l=1
Vd3 d3 0 0.9
Vg3 g3 0 0.9

** Test 4: W=10 L=4
XM4 d4 g4 vdd vdd sky130_fd_pr__pfet_01v8 w=10 l=4
Vd4 d4 0 0.9
Vg4 g4 0 0.9

Vdd vdd 0 1.8

.control
    op
    echo "W=4 L=4: Vth = $&@m.xm1.msky130_fd_pr__pfet_01v8[vth]  Id = $&@m.xm1.msky130_fd_pr__pfet_01v8[id]"
    echo "W=8 L=1: Vth = $&@m.xm2.msky130_fd_pr__pfet_01v8[vth]  Id = $&@m.xm2.msky130_fd_pr__pfet_01v8[id]"
    echo "W=4 L=1: Vth = $&@m.xm3.msky130_fd_pr__pfet_01v8[vth]  Id = $&@m.xm3.msky130_fd_pr__pfet_01v8[id]"
    echo "W=10 L=4: Vth = $&@m.xm4.msky130_fd_pr__pfet_01v8[vth]  Id = $&@m.xm4.msky130_fd_pr__pfet_01v8[id]"
.endc

.end

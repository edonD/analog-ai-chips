** tb_diag2.spice — Detailed diagnosis of Config D

.param mc_mm_switch=0
.param mc_pr_switch=0
.option scale=1e-6

.lib "/home/ubuntu/.volare/sky130A/libs.tech/combined/continuous/sky130.lib.spice" tt

** Config D: K=4, NMOS L=8, LVT PMOS W=0.42 L=8
XM3 nbias nbias vdd vdd sky130_fd_pr__pfet_01v8_lvt w=0.42 l=8
XM4 out_n nbias vdd vdd sky130_fd_pr__pfet_01v8_lvt w=0.42 l=8
XM1 nbias nbias 0 0 sky130_fd_pr__nfet_01v8 w=1 l=8
XM2 out_n nbias src_m2 0 sky130_fd_pr__nfet_01v8 w=4 l=8
XR1 src_m2 0 0 sky130_fd_pr__res_xhigh_po w=0.35 l=21

XM7 iref_out nbias vdd vdd sky130_fd_pr__pfet_01v8_lvt w=0.42 l=8
Vload iref_out 0 0.9

Vdd vdd 0 1.8
.nodeset v(nbias)=0.6

.control
    foreach vdd_val 1.6 1.7 1.8 1.9 2.0
        alter Vdd = $vdd_val
        op
        echo "=== VDD = $vdd_val ==="
        echo "nbias = $&v(nbias)"
        echo "out_n = $&v(out_n)"
        echo "src_m2 = $&v(src_m2)"

        let iref = abs(@m.xm7.msky130_fd_pr__pfet_01v8_lvt[id]) * 1e9
        echo "Iref = $&iref nA"

        let m1_id = @m.xm1.msky130_fd_pr__nfet_01v8[id] * 1e9
        let m2_id = @m.xm2.msky130_fd_pr__nfet_01v8[id] * 1e9
        echo "M1_id = $&m1_id nA  M2_id = $&m2_id nA"

        let m1_vgs = @m.xm1.msky130_fd_pr__nfet_01v8[vgs]
        let m2_vgs = @m.xm2.msky130_fd_pr__nfet_01v8[vgs]
        let m1_vth = @m.xm1.msky130_fd_pr__nfet_01v8[vth]
        let m2_vth = @m.xm2.msky130_fd_pr__nfet_01v8[vth]
        let m1_vds = @m.xm1.msky130_fd_pr__nfet_01v8[vds]
        let m2_vds = @m.xm2.msky130_fd_pr__nfet_01v8[vds]
        echo "M1: Vgs=$&m1_vgs Vth=$&m1_vth Vov=$&m1_vgs-$&m1_vth Vds=$&m1_vds"
        echo "M2: Vgs=$&m2_vgs Vth=$&m2_vth Vds=$&m2_vds"

        let delta_vgs = m1_vgs - m2_vgs
        echo "Vgs1-Vgs2 = $&delta_vgs (should = I*R1)"

        ** Effective R1
        let r1_eff = v(src_m2) / (m2_id * 1e-9)
        echo "R1_eff = $&r1_eff ohm"

        let pmos_vsg = abs(@m.xm3.msky130_fd_pr__pfet_01v8_lvt[vgs])
        let pmos_vth = abs(@m.xm3.msky130_fd_pr__pfet_01v8_lvt[vth])
        echo "PMOS: Vsg=$&pmos_vsg |Vth|=$&pmos_vth Vov=$&pmos_vsg-$&pmos_vth"
        echo ""
    end
.endc

.end

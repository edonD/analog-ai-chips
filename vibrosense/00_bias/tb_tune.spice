** tb_tune.spice — Tune R1 for 500nA at VDD=1.8V with Config D topology
** M1=1/8 M2=4/8 K=4, standard PMOS, long L

.param mc_mm_switch=0
.param mc_pr_switch=0
.option scale=1e-6

.lib "/home/ubuntu/.volare/sky130A/libs.tech/combined/continuous/sky130.lib.spice" tt

** Config: PMOS W=1 L=8, NMOS M1=1/8 M2=4/8, R1 varied
** R1 = 2578 * (l/0.35) ohm

** R1 = 155k (l=21)
XM3a nba nba vdd vdd sky130_fd_pr__pfet_01v8 w=1 l=8
XM4a outa nba vdd vdd sky130_fd_pr__pfet_01v8 w=1 l=8
XM1a nba nba 0 0 sky130_fd_pr__nfet_01v8 w=1 l=8
XM2a outa nba srca 0 sky130_fd_pr__nfet_01v8 w=4 l=8
XR1a srca 0 0 sky130_fd_pr__res_xhigh_po w=0.35 l=21
XM7a irefa nba vdd vdd sky130_fd_pr__pfet_01v8 w=1 l=8
VLa irefa 0 0.9

** R1 = 110k (l=15)
XM3b nbb nbb vdd vdd sky130_fd_pr__pfet_01v8 w=1 l=8
XM4b outb nbb vdd vdd sky130_fd_pr__pfet_01v8 w=1 l=8
XM1b nbb nbb 0 0 sky130_fd_pr__nfet_01v8 w=1 l=8
XM2b outb nbb srcb 0 sky130_fd_pr__nfet_01v8 w=4 l=8
XR1b srcb 0 0 sky130_fd_pr__res_xhigh_po w=0.35 l=15
XM7b irefb nbb vdd vdd sky130_fd_pr__pfet_01v8 w=1 l=8
VLb irefb 0 0.9

** R1 = 88k (l=12)
XM3c nbc nbc vdd vdd sky130_fd_pr__pfet_01v8 w=1 l=8
XM4c outc nbc vdd vdd sky130_fd_pr__pfet_01v8 w=1 l=8
XM1c nbc nbc 0 0 sky130_fd_pr__nfet_01v8 w=1 l=8
XM2c outc nbc srcc 0 sky130_fd_pr__nfet_01v8 w=4 l=8
XR1c srcc 0 0 sky130_fd_pr__res_xhigh_po w=0.35 l=12
XM7c irefc nbc vdd vdd sky130_fd_pr__pfet_01v8 w=1 l=8
VLc irefc 0 0.9

** PMOS W=0.5 L=8 (smaller PMOS)
XM3d nbd nbd vdd vdd sky130_fd_pr__pfet_01v8 w=0.5 l=8
XM4d outd nbd vdd vdd sky130_fd_pr__pfet_01v8 w=0.5 l=8
XM1d nbd nbd 0 0 sky130_fd_pr__nfet_01v8 w=1 l=8
XM2d outd nbd srcd 0 sky130_fd_pr__nfet_01v8 w=4 l=8
XR1d srcd 0 0 sky130_fd_pr__res_xhigh_po w=0.35 l=21
XM7d irefd nbd vdd vdd sky130_fd_pr__pfet_01v8 w=0.5 l=8
VLd irefd 0 0.9

Vdd vdd 0 1.8
.nodeset v(nba)=0.7 v(nbb)=0.7 v(nbc)=0.7 v(nbd)=0.7

.control
    op
    echo "=== At VDD=1.8V ==="
    let ia = abs(@m.xm7a.msky130_fd_pr__pfet_01v8[id]) * 1e9
    let m1a = @m.xm1a.msky130_fd_pr__nfet_01v8[id] * 1e9
    let m2a = @m.xm2a.msky130_fd_pr__nfet_01v8[id] * 1e9
    echo "A(R155k P1): I=$&ia  M1=$&m1a M2=$&m2a nb=$&v(nba) on=$&v(outa)"

    let ib = abs(@m.xm7b.msky130_fd_pr__pfet_01v8[id]) * 1e9
    let m1b = @m.xm1b.msky130_fd_pr__nfet_01v8[id] * 1e9
    let m2b = @m.xm2b.msky130_fd_pr__nfet_01v8[id] * 1e9
    echo "B(R110k P1): I=$&ib  M1=$&m1b M2=$&m2b nb=$&v(nbb) on=$&v(outb)"

    let ic = abs(@m.xm7c.msky130_fd_pr__pfet_01v8[id]) * 1e9
    let m1c = @m.xm1c.msky130_fd_pr__nfet_01v8[id] * 1e9
    let m2c = @m.xm2c.msky130_fd_pr__nfet_01v8[id] * 1e9
    echo "C(R88k P1): I=$&ic  M1=$&m1c M2=$&m2c nb=$&v(nbc) on=$&v(outc)"

    let id_v = abs(@m.xm7d.msky130_fd_pr__pfet_01v8[id]) * 1e9
    let m1d = @m.xm1d.msky130_fd_pr__nfet_01v8[id] * 1e9
    let m2d = @m.xm2d.msky130_fd_pr__nfet_01v8[id] * 1e9
    echo "D(R155k P0.5): I=$&id_v  M1=$&m1d M2=$&m2d nb=$&v(nbd) on=$&v(outd)"

    ** Now check supply sensitivity for best configs
    echo ""
    echo "=== Supply sweep ==="
    foreach vdd_val 1.6 1.8 2.0
        alter Vdd = $vdd_val
        op
        let ia = abs(@m.xm7a.msky130_fd_pr__pfet_01v8[id]) * 1e9
        let m1a = @m.xm1a.msky130_fd_pr__nfet_01v8[id] * 1e9
        let m2a = @m.xm2a.msky130_fd_pr__nfet_01v8[id] * 1e9
        let m4a = @m.xm4a.msky130_fd_pr__pfet_01v8[vds]
        echo "VDD=$vdd_val A: I=$&ia M1=$&m1a M2=$&m2a M4vds=$&m4a on=$&v(outa)"
    end
.endc

.end

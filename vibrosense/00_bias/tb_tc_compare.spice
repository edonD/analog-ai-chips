** tb_tc_compare.spice — Compare TC of different configurations

.param mc_mm_switch=0
.param mc_pr_switch=0
.option scale=1e-6

.lib "/home/ubuntu/.volare/sky130A/libs.tech/combined/continuous/sky130.lib.spice" tt

** Config A: Original (PMOS W=1.5 L=4, NMOS M1=2/4 M2=8/4, R1=120k)
XM3a nba nba vdd vdd sky130_fd_pr__pfet_01v8 w=1.5 l=4
XM4a outa nba vdd vdd sky130_fd_pr__pfet_01v8 w=1.5 l=4
XM1a nba nba 0 0 sky130_fd_pr__nfet_01v8 w=2 l=4
XM2a outa nba srca 0 sky130_fd_pr__nfet_01v8 w=8 l=4
XR1a srca 0 0 sky130_fd_pr__res_xhigh_po w=0.35 l=21
XM7a irefa nba vdd vdd sky130_fd_pr__pfet_01v8 w=1.5 l=4
VLa irefa 0 0.9

** Config B: LVT PMOS design (W=0.42 L=8, NMOS M1=1/8 M2=4/8)
XM3b nbb nbb vdd vdd sky130_fd_pr__pfet_01v8_lvt w=0.42 l=8
XM4b outb nbb vdd vdd sky130_fd_pr__pfet_01v8_lvt w=0.42 l=8
XM1b nbb nbb 0 0 sky130_fd_pr__nfet_01v8 w=1 l=8
XM2b outb nbb srcb 0 sky130_fd_pr__nfet_01v8 w=4 l=8
XR1b srcb 0 0 sky130_fd_pr__res_xhigh_po w=0.35 l=21
XM7b irefb nbb vdd vdd sky130_fd_pr__pfet_01v8_lvt w=0.42 l=8
VLb irefb 0 0.9

** Config C: Program original (PMOS W=4 L=4, NMOS M1=2/4 M2=8/4, R1=120k)
XM3c nbc nbc vdd vdd sky130_fd_pr__pfet_01v8 w=4 l=4
XM4c outc nbc vdd vdd sky130_fd_pr__pfet_01v8 w=4 l=4
XM1c nbc nbc 0 0 sky130_fd_pr__nfet_01v8 w=2 l=4
XM2c outc nbc srcc 0 sky130_fd_pr__nfet_01v8 w=8 l=4
XR1c srcc 0 0 sky130_fd_pr__res_xhigh_po w=0.35 l=21
XM7c irefc nbc vdd vdd sky130_fd_pr__pfet_01v8 w=4 l=4
VLc irefc 0 0.9

Vdd vdd 0 1.8
.nodeset v(nba)=0.62 v(nbb)=0.7 v(nbc)=0.62

.control
    foreach temp_val -40 0 27 85
        set temp = $temp_val
        op
        let ia = abs(@m.xm7a.msky130_fd_pr__pfet_01v8[id]) * 1e9
        let ib = abs(@m.xm7b.msky130_fd_pr__pfet_01v8_lvt[id]) * 1e9
        let ic = abs(@m.xm7c.msky130_fd_pr__pfet_01v8[id]) * 1e9
        echo "T=$temp_val: A(orig)=$&ia  B(LVT)=$&ib  C(prog)=$&ic"
    end
.endc

.end

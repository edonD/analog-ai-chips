** tb_cascode.spice — NMOS cascode in M2 branch to fix M2 triode issue

.param mc_mm_switch=0
.param mc_pr_switch=0
.option scale=1e-6

.lib "/home/ubuntu/.volare/sky130A/libs.tech/combined/continuous/sky130.lib.spice" tt

** ===== Config A: LVT PMOS + NMOS cascode gate=nbias =====
** PMOS mirror (LVT)
XM3a nba nba vdd vdd sky130_fd_pr__pfet_01v8_lvt w=0.42 l=8
XM4a outa nba vdd vdd sky130_fd_pr__pfet_01v8_lvt w=0.42 l=8
** NMOS pair
XM1a nba nba 0 0 sky130_fd_pr__nfet_01v8 w=1 l=8
** NMOS cascode in M2 branch, gate=nbias
XMca outa nba m2da 0 sky130_fd_pr__nfet_01v8 w=4 l=8
XM2a m2da nba srca 0 sky130_fd_pr__nfet_01v8 w=4 l=8
XR1a srca 0 0 sky130_fd_pr__res_xhigh_po w=0.35 l=21
** Output mirror
XM7a irefa nba vdd vdd sky130_fd_pr__pfet_01v8_lvt w=0.42 l=8
VLa irefa 0 0.9

** ===== Config B: LVT PMOS + NMOS cascode gate=vdd (max headroom) =====
XM3b nbb nbb vdd vdd sky130_fd_pr__pfet_01v8_lvt w=0.42 l=8
XM4b outb nbb vdd vdd sky130_fd_pr__pfet_01v8_lvt w=0.42 l=8
XM1b nbb nbb 0 0 sky130_fd_pr__nfet_01v8 w=1 l=8
** NMOS cascode gate=vdd
XMcb outb vdd m2db 0 sky130_fd_pr__nfet_01v8 w=4 l=8
XM2b m2db nbb srcb 0 sky130_fd_pr__nfet_01v8 w=4 l=8
XR1b srcb 0 0 sky130_fd_pr__res_xhigh_po w=0.35 l=21
XM7b irefb nbb vdd vdd sky130_fd_pr__pfet_01v8_lvt w=0.42 l=8
VLb irefb 0 0.9

** ===== Config C: LVT PMOS + NMOS cascode gate=separate bias (out_n) =====
XM3c nbc nbc vdd vdd sky130_fd_pr__pfet_01v8_lvt w=0.42 l=8
XM4c outc nbc vdd vdd sky130_fd_pr__pfet_01v8_lvt w=0.42 l=8
XM1c nbc nbc 0 0 sky130_fd_pr__nfet_01v8 w=1 l=8
** NMOS cascode gate=out_n (regulated cascode-like)
XMcc outc outc m2dc 0 sky130_fd_pr__nfet_01v8 w=4 l=8
XM2c m2dc nbc srcc 0 sky130_fd_pr__nfet_01v8 w=4 l=8
XR1c srcc 0 0 sky130_fd_pr__res_xhigh_po w=0.35 l=21
XM7c irefc nbc vdd vdd sky130_fd_pr__pfet_01v8_lvt w=0.42 l=8
VLc irefc 0 0.9

** ===== Config D: No cascode baseline (from prior work) =====
XM3d nbd nbd vdd vdd sky130_fd_pr__pfet_01v8_lvt w=0.42 l=8
XM4d outd nbd vdd vdd sky130_fd_pr__pfet_01v8_lvt w=0.42 l=8
XM1d nbd nbd 0 0 sky130_fd_pr__nfet_01v8 w=1 l=8
XM2d outd nbd srcd 0 sky130_fd_pr__nfet_01v8 w=4 l=8
XR1d srcd 0 0 sky130_fd_pr__res_xhigh_po w=0.35 l=21
XM7d irefd nbd vdd vdd sky130_fd_pr__pfet_01v8_lvt w=0.42 l=8
VLd irefd 0 0.9

Vdd vdd 0 1.8
.nodeset v(nba)=0.62 v(nbb)=0.62 v(nbc)=0.62 v(nbd)=0.62

.control
    op
    echo "========================================"
    echo "=== Config A: Cascode gate=nbias ==="
    echo "========================================"
    let ia = abs(@m.xm7a.msky130_fd_pr__pfet_01v8_lvt[id]) * 1e9
    echo "Iref = $&ia nA"
    echo "nbias = $&v(nba)"
    echo "out_n = $&v(outa)"
    echo "m2_drain = $&v(m2da)"
    echo "src_m2 = $&v(srca)"
    echo "M2a Vds = $&@m.xm2a.msky130_fd_pr__nfet_01v8[vds]"
    let vov2a = @m.xm2a.msky130_fd_pr__nfet_01v8[vgs] - @m.xm2a.msky130_fd_pr__nfet_01v8[vth]
    echo "M2a Vov = $&vov2a"
    echo "M4a Vds = $&@m.xm4a.msky130_fd_pr__pfet_01v8_lvt[vds]"
    echo "Mca Vds = $&@m.xmca.msky130_fd_pr__nfet_01v8[vds]"
    let i1a = abs(@m.xm1a.msky130_fd_pr__nfet_01v8[id]) * 1e9
    let i2a = abs(@m.xm2a.msky130_fd_pr__nfet_01v8[id]) * 1e9
    echo "M1 Id = $&i1a nA, M2 Id = $&i2a nA"

    echo ""
    echo "========================================"
    echo "=== Config B: Cascode gate=vdd ==="
    echo "========================================"
    let ib = abs(@m.xm7b.msky130_fd_pr__pfet_01v8_lvt[id]) * 1e9
    echo "Iref = $&ib nA"
    echo "nbias = $&v(nbb)"
    echo "out_n = $&v(outb)"
    echo "m2_drain = $&v(m2db)"
    echo "src_m2 = $&v(srcb)"
    echo "M2b Vds = $&@m.xm2b.msky130_fd_pr__nfet_01v8[vds]"
    let vov2b = @m.xm2b.msky130_fd_pr__nfet_01v8[vgs] - @m.xm2b.msky130_fd_pr__nfet_01v8[vth]
    echo "M2b Vov = $&vov2b"
    echo "M4b Vds = $&@m.xm4b.msky130_fd_pr__pfet_01v8_lvt[vds]"
    echo "Mcb Vds = $&@m.xmcb.msky130_fd_pr__nfet_01v8[vds]"
    let i1b = abs(@m.xm1b.msky130_fd_pr__nfet_01v8[id]) * 1e9
    let i2b = abs(@m.xm2b.msky130_fd_pr__nfet_01v8[id]) * 1e9
    echo "M1 Id = $&i1b nA, M2 Id = $&i2b nA"

    echo ""
    echo "========================================"
    echo "=== Config C: Cascode gate=out_n ==="
    echo "========================================"
    let ic = abs(@m.xm7c.msky130_fd_pr__pfet_01v8_lvt[id]) * 1e9
    echo "Iref = $&ic nA"
    echo "nbias = $&v(nbc)"
    echo "out_n = $&v(outc)"
    echo "m2_drain = $&v(m2dc)"
    echo "src_m2 = $&v(srcc)"
    echo "M2c Vds = $&@m.xm2c.msky130_fd_pr__nfet_01v8[vds]"
    let vov2c = @m.xm2c.msky130_fd_pr__nfet_01v8[vgs] - @m.xm2c.msky130_fd_pr__nfet_01v8[vth]
    echo "M2c Vov = $&vov2c"
    echo "M4c Vds = $&@m.xm4c.msky130_fd_pr__pfet_01v8_lvt[vds]"
    echo "Mcc Vds = $&@m.xmcc.msky130_fd_pr__nfet_01v8[vds]"
    let i1c = abs(@m.xm1c.msky130_fd_pr__nfet_01v8[id]) * 1e9
    let i2c = abs(@m.xm2c.msky130_fd_pr__nfet_01v8[id]) * 1e9
    echo "M1 Id = $&i1c nA, M2 Id = $&i2c nA"

    echo ""
    echo "========================================"
    echo "=== Config D: No cascode (baseline) ==="
    echo "========================================"
    let id_val = abs(@m.xm7d.msky130_fd_pr__pfet_01v8_lvt[id]) * 1e9
    echo "Iref = $&id_val nA"
    echo "nbias = $&v(nbd)"
    echo "out_n = $&v(outd)"
    echo "src_m2 = $&v(srcd)"
    echo "M2d Vds = $&@m.xm2d.msky130_fd_pr__nfet_01v8[vds]"
    let vov2d = @m.xm2d.msky130_fd_pr__nfet_01v8[vgs] - @m.xm2d.msky130_fd_pr__nfet_01v8[vth]
    echo "M2d Vov = $&vov2d"
    echo "M4d Vds = $&@m.xm4d.msky130_fd_pr__pfet_01v8_lvt[vds]"
    let i1d = abs(@m.xm1d.msky130_fd_pr__nfet_01v8[id]) * 1e9
    let i2d = abs(@m.xm2d.msky130_fd_pr__nfet_01v8[id]) * 1e9
    echo "M1 Id = $&i1d nA, M2 Id = $&i2d nA"
.endc

.end

** tb_lvt.spice — Test with LVT PMOS (|Vth| ~ 0.45V)

.param mc_mm_switch=0
.param mc_pr_switch=0
.option scale=1e-6

.lib "/home/ubuntu/.volare/sky130A/libs.tech/combined/continuous/sky130.lib.spice" tt

** Core beta-multiplier with LVT PMOS
XM3 nbias nbias vdd vdd sky130_fd_pr__pfet_01v8_lvt w=2 l=4
XM4 out_n nbias vdd vdd sky130_fd_pr__pfet_01v8_lvt w=2 l=4
XM1 nbias nbias 0 0 sky130_fd_pr__nfet_01v8 w=2 l=4
XM2 out_n nbias src_m2 0 sky130_fd_pr__nfet_01v8 w=8 l=4
XR1 src_m2 0 0 sky130_fd_pr__res_xhigh_po w=0.35 l=21

** Output mirror
XM7 iref_out nbias vdd vdd sky130_fd_pr__pfet_01v8_lvt w=2 l=4
Vload iref_out 0 0.9

Vdd vdd 0 1.8
.nodeset v(nbias)=0.62

.control
    foreach vdd_val 1.6 1.7 1.8 1.9 2.0
        alter Vdd = $vdd_val
        op
        let iref_v = abs(@m.xm7.msky130_fd_pr__pfet_01v8_lvt[id]) * 1e9
        let nb = v(nbias)
        let on = v(out_n)
        let sm = v(src_m2)
        let m4vds = @m.xm4.msky130_fd_pr__pfet_01v8_lvt[vds]
        let pmos_od = abs(@m.xm3.msky130_fd_pr__pfet_01v8_lvt[vgs]) - abs(@m.xm3.msky130_fd_pr__pfet_01v8_lvt[vth])
        let m1i = @m.xm1.msky130_fd_pr__nfet_01v8[id] * 1e9
        let m2i = @m.xm2.msky130_fd_pr__nfet_01v8[id] * 1e9
        echo "VDD=$vdd_val: Iref=$&iref_v nA  nb=$&nb  on=$&on  sm=$&sm  M4vds=$&m4vds  od=$&pmos_od  M1=$&m1i M2=$&m2i"
    end
.endc

.end

** tb_explore.spice — Force M4 into saturation with nodeset

.param mc_mm_switch=0
.param mc_pr_switch=0
.option scale=1e-6

.lib "/home/ubuntu/.volare/sky130A/libs.tech/combined/continuous/sky130.lib.spice" tt

** M1=2/4 M2=8/4 (K=4), PMOS=4/4, R1~120k
XM3 nbias nbias vdd vdd sky130_fd_pr__pfet_01v8 w=4 l=4
XM4 out_n nbias vdd vdd sky130_fd_pr__pfet_01v8 w=4 l=4
XM1 nbias nbias 0 0 sky130_fd_pr__nfet_01v8 w=2 l=4
XM2 out_n nbias src_m2 0 sky130_fd_pr__nfet_01v8 w=8 l=4
XR1 src_m2 0 0 sky130_fd_pr__res_xhigh_po w=0.35 l=22

Vdd vdd 0 1.8

** Try nodeset that places out_n in saturation range
.nodeset v(nbias)=0.63 v(out_n)=1.0 v(src_m2)=0.05

.control
    op
    echo "=== Attempt: M4 saturation ==="
    echo "M1_Id = $&@m.xm1.msky130_fd_pr__nfet_01v8[id]"
    echo "M4_Id = $&@m.xm4.msky130_fd_pr__pfet_01v8[id]"
    echo "M3_Id = $&@m.xm3.msky130_fd_pr__pfet_01v8[id]"
    echo "nbias = $&v(nbias)"
    echo "out_n = $&v(out_n)"
    echo "src_m2 = $&v(src_m2)"
    let pmos_od = abs(@m.xm3.msky130_fd_pr__pfet_01v8[vgs]) - abs(@m.xm3.msky130_fd_pr__pfet_01v8[vth])
    echo "PMOS_od = $&pmos_od"
    echo "M4_Vds = $&@m.xm4.msky130_fd_pr__pfet_01v8[vds]"
    echo "M3_Vds = $&@m.xm3.msky130_fd_pr__pfet_01v8[vds]"
    echo "mirror_ratio = $&@m.xm4.msky130_fd_pr__pfet_01v8[id] / $&@m.xm3.msky130_fd_pr__pfet_01v8[id]"
    let ratio = abs(@m.xm4.msky130_fd_pr__pfet_01v8[id]) / abs(@m.xm3.msky130_fd_pr__pfet_01v8[id])
    echo "Ratio M4/M3 = $&ratio"
    let power = -i(Vdd) * 1.8
    echo "Power = $&power"
.endc

.end

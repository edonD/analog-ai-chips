** tb_biasdist_dc.spice — DC operating point for bias_generator_full
** Measures all 4 bias voltages at TT 27C 1.8V

.param mc_mm_switch=0
.param mc_pr_switch=0
.option scale=1e-6
.lib "/home/ubuntu/.volare/sky130A/libs.tech/combined/continuous/sky130.lib.spice" tt

.include "design_full.cir"

Xbias vdd gnd iref_out vbn vbcn vbp vbcp  bias_generator_full
Vdd vdd gnd 1.8
Riref iref_out gnd 3560

.nodeset v(vbn)=0.65 v(vbp)=0.73 v(vbcn)=0.88 v(vbcp)=0.475
.nodeset v(xbias.out_n)=0.65 v(xbias.vbias)=0.68
+ v(xbias.od1)=0.85 v(xbias.otail)=0.15 v(xbias.src_m2)=0.06 v(xbias.mid_r)=0.03

.control
op

echo "=== BIAS DISTRIBUTION DC RESULTS (TT 27C 1.8V) ==="
let m_iref_nA = @Riref[i] * 1e9
let m_vbn = v(vbn)
let m_vbcn = v(vbcn)
let m_vbp = v(vbp)
let m_vbcp = v(vbcp)
let m_vbcn_diff = v(vbcn) - v(vbn)
let m_vbcp_diff = v(vbp) - v(vbcp)

echo ""
echo "Iref  = $&m_iref_nA nA"
echo "vbn   = $&m_vbn V"
echo "vbcn  = $&m_vbcn V"
echo "vbp   = $&m_vbp V"
echo "vbcp  = $&m_vbcp V"
echo "vbcn - vbn = $&m_vbcn_diff V"
echo "vbp - vbcp = $&m_vbcp_diff V"

echo ""
echo "=== PASS/FAIL ==="

** vbn: 0.60-0.70V
if m_vbn > 0.60
  if m_vbn < 0.70
    echo "vbn:  PASS ($&m_vbn in 0.60-0.70)"
  else
    echo "vbn:  FAIL ($&m_vbn > 0.70)"
  end
else
  echo "vbn:  FAIL ($&m_vbn < 0.60)"
end

** vbcn: 0.82-0.95V
if m_vbcn > 0.82
  if m_vbcn < 0.95
    echo "vbcn: PASS ($&m_vbcn in 0.82-0.95)"
  else
    echo "vbcn: FAIL ($&m_vbcn > 0.95)"
  end
else
  echo "vbcn: FAIL ($&m_vbcn < 0.82)"
end

** vbp: 0.68-0.78V (corrected from program.md; OTA testbenches use 0.73V)
if m_vbp > 0.68
  if m_vbp < 0.78
    echo "vbp:  PASS ($&m_vbp in 0.68-0.78)"
  else
    echo "vbp:  FAIL ($&m_vbp > 0.78)"
  end
else
  echo "vbp:  FAIL ($&m_vbp < 0.68)"
end

** vbcp: 0.42-0.53V
if m_vbcp > 0.42
  if m_vbcp < 0.53
    echo "vbcp: PASS ($&m_vbcp in 0.42-0.53)"
  else
    echo "vbcp: FAIL ($&m_vbcp > 0.53)"
  end
else
  echo "vbcp: FAIL ($&m_vbcp < 0.42)"
end

** Iref: 480-530 nA
if m_iref_nA > 480
  if m_iref_nA < 530
    echo "Iref: PASS ($&m_iref_nA in 480-530)"
  else
    echo "Iref: FAIL ($&m_iref_nA > 530)"
  end
else
  echo "Iref: FAIL ($&m_iref_nA < 480)"
end

.endc

.end

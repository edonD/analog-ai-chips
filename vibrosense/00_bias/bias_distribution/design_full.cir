** VibroSense Block 00 Extension: Bias Distribution
** Full bias generator with 4 OTA bias voltage outputs
** SKY130A Process — design_full.cir
**
** Extended from ../design.cir (FROZEN) with four new bias outputs:
**   - vbn:  ground-referred NMOS bias (~0.65V) = internal nbias (renamed)
**   - vbcn: ground-referred NMOS cascode bias (~0.88V) via NMOS diode to gnd
**   - vbp:  VDD-tracking PMOS bias (~0.69V) via resistor from VDD
**   - vbcp: VDD-tracking PMOS cascode bias (~0.475V) via resistor from vbp
**
** NOTE: All new MOSFETs use W>=0.84u to avoid SKY130 ss-corner model bin
** issue with W=0.42u (Pclm<0 in BSIM4 bin .41).
** NOTE: vbp uses resistor (not PMOS diode) for better temperature stability.
** The resistor's positive TC partially cancels the NMOS sink current TC.
**
** All dimensions in microns. Use with:
**   .option scale=1e-6
**   .lib ".../combined/continuous/sky130.lib.spice" <corner>

.subckt bias_generator_full vdd gnd iref_out vbn vbcn vbp vbcp

** ================================================================
** CORE: identical to ../design.cir with nbias renamed to vbn
** Internal node vbias stays internal (NOT exported as vbp)
** ================================================================

** ===== PMOS Current Mirror (gate = vbias from OTA) =====
XM3 vbn vbias vdd vdd sky130_fd_pr__pfet_01v8 w=4 l=4
XM4 out_n vbias vdd vdd sky130_fd_pr__pfet_01v8 w=4 l=4

** ===== NMOS Pair (K = W2/W1 = 4) =====
XM1 vbn vbn gnd gnd sky130_fd_pr__nfet_01v8 w=2 l=4
XM2 out_n vbn src_m2 gnd sky130_fd_pr__nfet_01v8 w=8 l=4

** ===== R1: TC-compensated resistor =====
XR1a src_m2 mid_r gnd sky130_fd_pr__res_xhigh_po w=0.35 l=7.09
XR1b mid_r gnd gnd sky130_fd_pr__res_iso_pw w=0.35 l=6.56

** ===== Swapped OTA: forces V(out_n) = V(vbn) =====
XMo1 od1 out_n otail gnd sky130_fd_pr__nfet_01v8 w=1 l=4
XMo2 vbias vbn otail gnd sky130_fd_pr__nfet_01v8 w=1 l=4
XMo3 od1 od1 vdd vdd sky130_fd_pr__pfet_01v8 w=2 l=4
XMo4 vbias od1 vdd vdd sky130_fd_pr__pfet_01v8 w=2 l=4
XMo5 otail vbn gnd gnd sky130_fd_pr__nfet_01v8 w=1 l=4

** ===== Dominant-Pole Compensation =====
XC_comp od1 gnd gnd sky130_fd_pr__cap_mim_m3_1 w=50 l=50

** ===== Output Mirror (PMOS, matches M3/M4) =====
XM7 iref_out vbias vdd vdd sky130_fd_pr__pfet_01v8 w=4 l=4

** ===== Anti-Deadlock Leaker =====
XM6 vbias gnd gnd gnd sky130_fd_pr__nfet_01v8 w=0.5 l=0.5

** ===== RC Startup Circuit =====
XC_gs vdd gs gnd sky130_fd_pr__cap_mim_m3_1 w=25 l=50
XR_gs gs gnd gnd sky130_fd_pr__res_xhigh_po w=0.35 l=1360
XMsw vbias gs vbn gnd sky130_fd_pr__nfet_01v8 w=4 l=0.5

** ================================================================
** NEW BIAS DISTRIBUTION OUTPUTS
** ================================================================

** ===== vbcn generation (ground-referred, ~0.88V) =====
** NMOS diode to ground: Vgs sets vbcn directly (no body effect)
** PMOS mirror from vbias provides ~500nA operating current
** W=0.84 L=14 NMOS diode at 500nA → Vgs≈0.88V
XM8   vbcn vbias vdd vdd sky130_fd_pr__pfet_01v8 w=4 l=4
XMbcn vbcn vbcn  gnd gnd sky130_fd_pr__nfet_01v8 w=0.84 l=20

** ===== vbp generation (VDD-tracking, ~0.69V) =====
** Resistor from VDD to vbp + NMOS current sink (gate=vbn)
** VDD-tracking: vbp = VDD - I_sink*R, I_sink is ground-referred
** Resistor TC (+2500ppm/C) partially compensates NMOS current TC,
** giving much better temperature stability than PMOS diode approach
** (±48mV vs ±145mV across 5 corners x 3 temps)
XRvbp  vdd vbp gnd sky130_fd_pr__res_xhigh_po w=0.35 l=300
XMvbp_sink vbp vbn gnd gnd sky130_fd_pr__nfet_01v8 w=1.7 l=4

** ===== vbcp generation (VDD-tracking, ~0.475V) =====
** Resistor from vbp to vbcp + NMOS current sink (gate=vbn)
** VDD-tracking because vbp tracks VDD and I_sink is ground-referenced
XRbcp  vbp vbcp gnd sky130_fd_pr__res_xhigh_po w=0.35 l=650
XMbcp_sink vbcp vbn  gnd gnd sky130_fd_pr__nfet_01v8 w=0.84 l=16

.ends bias_generator_full

** Regression: iref from both subcircuits must match within 2%
** Compares frozen bias_generator vs new bias_generator_full

.param mc_mm_switch=0
.param mc_pr_switch=0
.option scale=1e-6
.lib "/home/ubuntu/.volare/sky130A/libs.tech/combined/continuous/sky130.lib.spice" tt

.include "../design.cir"
.include "design_full.cir"

Xold vdd gnd iref_old              bias_generator
Xnew vdd gnd iref_new vbn vbcn vbp vbcp  bias_generator_full

Vdd vdd gnd 1.8
Rold iref_old gnd 3560
Rnew iref_new gnd 3560

** Nodesets for convergence
** Old (frozen) circuit internal nodes
.nodeset v(xold.nbias)=0.65 v(xold.out_n)=0.65 v(xold.vbias)=0.55
+ v(xold.od1)=0.85 v(xold.otail)=0.15 v(xold.src_m2)=0.06 v(xold.mid_r)=0.03
** New circuit: vbn/vbp/vbcn/vbcp are top-level nets (ports)
.nodeset v(vbn)=0.65 v(vbp)=1.07 v(vbcn)=0.88 v(vbcp)=0.475
** New circuit internal nodes
.nodeset v(xnew.out_n)=0.65
+ v(xnew.od1)=0.85 v(xnew.otail)=0.15 v(xnew.src_m2)=0.06 v(xnew.mid_r)=0.03

.op

.control
op
let iref_old_nA = @Rold[i] * 1e9
let iref_new_nA = @Rnew[i] * 1e9
let delta_pct = abs(iref_old_nA - iref_new_nA) / abs(iref_old_nA) * 100
echo "=== REGRESSION RESULTS ==="
echo "iref_old_nA:"
print iref_old_nA
echo "iref_new_nA:"
print iref_new_nA
echo "delta_pct:"
print delta_pct
echo "=== BIAS VOLTAGES ==="
print v(vbn) v(vbcn) v(vbp) v(vbcp)
if delta_pct < 2.0
  echo "PASS: delta < 2%"
else
  echo "FAIL: delta >= 2%"
end
.endc

.end

** tb_biasdist_psrr.spice — VDD-tracking verification
** Sweeps VDD from 1.6 to 2.0V and measures dV/dVDD for all 4 outputs

.param mc_mm_switch=0
.param mc_pr_switch=0
.option scale=1e-6
.lib "/home/ubuntu/.volare/sky130A/libs.tech/combined/continuous/sky130.lib.spice" tt

.include "design_full.cir"

Xbias vdd gnd iref_out vbn vbcn vbp vbcp  bias_generator_full
Vdd vdd gnd 1.8
Riref iref_out gnd 3560

.nodeset v(vbn)=0.65 v(vbp)=0.73 v(vbcn)=0.88 v(vbcp)=0.475
.nodeset v(xbias.out_n)=0.65 v(xbias.vbias)=0.68
+ v(xbias.od1)=0.85 v(xbias.otail)=0.15 v(xbias.src_m2)=0.06 v(xbias.mid_r)=0.03

.dc Vdd 1.6 2.0 0.01

.control
run

echo "=== VDD TRACKING RESULTS ==="
echo ""

** Compute derivatives using finite differences around VDD=1.8V
** VDD=1.8V is at index (1.8-1.6)/0.01 = 20
let idx_lo = 19
let idx_hi = 21
let dvdd = 0.02

let dvbn  = (v(vbn)[idx_hi]  - v(vbn)[idx_lo])  / dvdd
let dvbcn = (v(vbcn)[idx_hi] - v(vbcn)[idx_lo]) / dvdd
let dvbp  = (v(vbp)[idx_hi]  - v(vbp)[idx_lo])  / dvdd
let dvbcp = (v(vbcp)[idx_hi] - v(vbcp)[idx_lo]) / dvdd

echo "dvbn/dVDD  = $&dvbn V/V  (should be < 0.15)"
echo "dvbcn/dVDD = $&dvbcn V/V  (should be < 0.15)"
echo "dvbp/dVDD  = $&dvbp V/V  (should be > 0.85)"
echo "dvbcp/dVDD = $&dvbcp V/V  (should be > 0.85)"
echo ""

** Also show absolute values at 1.6V, 1.8V, 2.0V
echo "=== VOLTAGE vs VDD ==="
echo "VDD=1.6V: vbn=$&v(vbn)[0] vbcn=$&v(vbcn)[0] vbp=$&v(vbp)[0] vbcp=$&v(vbcp)[0]"
echo "VDD=1.8V: vbn=$&v(vbn)[20] vbcn=$&v(vbcn)[20] vbp=$&v(vbp)[20] vbcp=$&v(vbcp)[20]"
echo "VDD=2.0V: vbn=$&v(vbn)[40] vbcn=$&v(vbcn)[40] vbp=$&v(vbp)[40] vbcp=$&v(vbcp)[40]"
echo ""

** Pass/fail
echo "=== PASS/FAIL ==="
if dvbn < 0.15
  echo "dvbn/dVDD:  PASS ($&dvbn < 0.15)"
else
  echo "dvbn/dVDD:  FAIL ($&dvbn >= 0.15)"
end
if dvbcn < 0.15
  echo "dvbcn/dVDD: PASS ($&dvbcn < 0.15)"
else
  echo "dvbcn/dVDD: FAIL ($&dvbcn >= 0.15)"
end
if dvbp > 0.85
  echo "dvbp/dVDD:  PASS ($&dvbp > 0.85)"
else
  echo "dvbp/dVDD:  FAIL ($&dvbp <= 0.85)"
end
if dvbcp > 0.85
  echo "dvbcp/dVDD: PASS ($&dvbcp > 0.85)"
else
  echo "dvbcp/dVDD: FAIL ($&dvbcp <= 0.85)"
end

** Save data for plotting
wrdata psrr_data v(vbn) v(vbcn) v(vbp) v(vbcp)

.endc

.end

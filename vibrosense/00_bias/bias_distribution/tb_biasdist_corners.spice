** tb_biasdist_corners.spice — 5 corners x 3 temperatures
** Verifies all 4 bias voltages across PVT
** Run via: python3 run_corners.py (generates individual sims per corner)

** This file serves as the template. The actual sweep is performed by
** run_corners.py which generates per-corner netlists and collects results.
** See run_corners.py for full results.

** Example single-corner simulation (TT 27C):
.param mc_mm_switch=0
.param mc_pr_switch=0
.option scale=1e-6
.lib "/home/ubuntu/.volare/sky130A/libs.tech/combined/continuous/sky130.lib.spice" tt

.include "design_full.cir"

Xbias vdd gnd iref_out vbn vbcn vbp vbcp  bias_generator_full
Vdd vdd gnd 1.8
Riref iref_out gnd 3560

.nodeset v(vbn)=0.65 v(vbp)=0.73 v(vbcn)=0.88 v(vbcp)=0.475

.control
echo "=== CORNER SWEEP RESULTS ==="
echo "Run python3 run_corners.py for full 5x3 sweep"
echo ""
echo "Single-point check (TT 27C):"
op
let iref_nA = @Riref[i] * 1e9
echo "vbn=$&v(vbn) vbcn=$&v(vbcn) vbp=$&v(vbp) vbcp=$&v(vbcp) Iref=$&iref_nA"
.endc

.end

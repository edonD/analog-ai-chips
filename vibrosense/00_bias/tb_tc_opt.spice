** tb_tc_opt.spice — Search for optimal TC by varying R1 and K
** Operating deeper in moderate inversion should give better TC

.param mc_mm_switch=0
.param mc_pr_switch=0
.option scale=1e-6

.lib "/home/ubuntu/.volare/sky130A/libs.tech/combined/continuous/sky130.lib.spice" tt

** Config A: Small R1 (more current → deeper moderate inversion)
** K=4, M1=1/8, M2=4/8, R1=40k (l=5.6), LVT PMOS W=0.42 L=8
XM3a nba nba vdd vdd sky130_fd_pr__pfet_01v8_lvt w=0.42 l=8
XM4a outa nba vdd vdd sky130_fd_pr__pfet_01v8_lvt w=0.42 l=8
XM1a nba nba 0 0 sky130_fd_pr__nfet_01v8 w=1 l=8
XM2a outa nba srca 0 sky130_fd_pr__nfet_01v8 w=4 l=8
XR1a srca 0 0 sky130_fd_pr__res_xhigh_po w=0.35 l=5.6
XM7a irefa nba vdd vdd sky130_fd_pr__pfet_01v8_lvt w=0.42 l=8
VLa irefa 0 0.9

** Config B: K=16, M1=1/8, M2=16/8, R1=155k
** Higher K → more ΔVgs → different TC balance
XM3b nbb nbb vdd vdd sky130_fd_pr__pfet_01v8_lvt w=0.42 l=8
XM4b outb nbb vdd vdd sky130_fd_pr__pfet_01v8_lvt w=0.42 l=8
XM1b nbb nbb 0 0 sky130_fd_pr__nfet_01v8 w=1 l=8
XM2b outb nbb srcb 0 sky130_fd_pr__nfet_01v8 w=16 l=8
XR1b srcb 0 0 sky130_fd_pr__res_xhigh_po w=0.35 l=21
XM7b irefb nbb vdd vdd sky130_fd_pr__pfet_01v8_lvt w=0.42 l=8
VLb irefb 0 0.9

** Config C: Very small R1 (R=20k, l=2.8), push NMOS into stronger inversion
** K=4, M1=0.5/8, M2=2/8 (smaller W for higher Vov)
XM3c nbc nbc vdd vdd sky130_fd_pr__pfet_01v8_lvt w=0.42 l=8
XM4c outc nbc vdd vdd sky130_fd_pr__pfet_01v8_lvt w=0.42 l=8
XM1c nbc nbc 0 0 sky130_fd_pr__nfet_01v8 w=0.5 l=8
XM2c outc nbc srcc 0 sky130_fd_pr__nfet_01v8 w=2 l=8
XR1c srcc 0 0 sky130_fd_pr__res_xhigh_po w=0.35 l=2.8
XM7c irefc nbc vdd vdd sky130_fd_pr__pfet_01v8_lvt w=0.42 l=8
VLc irefc 0 0.9

** Config D: Original PMOS (standard), NMOS M1=2/4, M2=8/4, but R1=60k (l=10.5)
** Push NMOS into moderate inversion
XM3d nbd nbd vdd vdd sky130_fd_pr__pfet_01v8 w=1.5 l=4
XM4d outd nbd vdd vdd sky130_fd_pr__pfet_01v8 w=1.5 l=4
XM1d nbd nbd 0 0 sky130_fd_pr__nfet_01v8 w=2 l=4
XM2d outd nbd srcd 0 sky130_fd_pr__nfet_01v8 w=8 l=4
XR1d srcd 0 0 sky130_fd_pr__res_xhigh_po w=0.35 l=10.5
XM7d irefd nbd vdd vdd sky130_fd_pr__pfet_01v8 w=1.5 l=4
VLd irefd 0 0.9

Vdd vdd 0 1.8
.nodeset v(nba)=0.7 v(nbb)=0.7 v(nbc)=0.7 v(nbd)=0.62

.control
    foreach temp_val -40 0 27 85
        set temp = $temp_val
        op
        let ia = abs(@m.xm7a.msky130_fd_pr__pfet_01v8_lvt[id]) * 1e9
        let ib = abs(@m.xm7b.msky130_fd_pr__pfet_01v8_lvt[id]) * 1e9
        let ic = abs(@m.xm7c.msky130_fd_pr__pfet_01v8_lvt[id]) * 1e9
        let id_v = abs(@m.xm7d.msky130_fd_pr__pfet_01v8[id]) * 1e9
        echo "T=$temp_val: A(R40k)=$&ia B(K16)=$&ib C(R20k)=$&ic D(stdP)=$&id_v"
    end
.endc

.end

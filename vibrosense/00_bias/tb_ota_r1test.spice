** tb_ota_r1test.spice — Verify R1 regulation in OTA beta-mult
** Test R1=77k, 155k, 310k one at a time using alter

.param mc_mm_switch=0
.param mc_pr_switch=0
.option scale=1e-6

.lib "/home/ubuntu/.volare/sky130A/libs.tech/combined/continuous/sky130.lib.spice" tt

** OTA-regulated beta-multiplier (same as tb_ota.spice)
XM3 nbias vbias vdd vdd sky130_fd_pr__pfet_01v8 w=4 l=4
XM4 out_n vbias vdd vdd sky130_fd_pr__pfet_01v8 w=4 l=4
XM1 nbias nbias 0 0 sky130_fd_pr__nfet_01v8 w=2 l=4
XM2 out_n nbias src_m2 0 sky130_fd_pr__nfet_01v8 w=8 l=4

** R1 as a voltage-controlled source we can alter
** Using parameterized resistor via subcircuit... actually just use fixed
** We'll test by creating separate netlists. For now test with l=21.
XR1 src_m2 0 0 sky130_fd_pr__res_xhigh_po w=0.35 l=21

** OTA
XMo1 od1 nbias otail 0 sky130_fd_pr__nfet_01v8 w=1 l=4
XMo2 vbias out_n otail 0 sky130_fd_pr__nfet_01v8 w=1 l=4
XMo3 od1 od1 vdd vdd sky130_fd_pr__pfet_01v8 w=2 l=4
XMo4 vbias od1 vdd vdd sky130_fd_pr__pfet_01v8 w=2 l=4
XMo5 otail nbias 0 0 sky130_fd_pr__nfet_01v8 w=0.5 l=8

** Output mirror — use vbias gate to match M3/M4
XM7 iref_out vbias vdd vdd sky130_fd_pr__pfet_01v8 w=4 l=4
Vload iref_out 0 0.9

Vdd vdd 0 1.8
.nodeset v(nbias)=0.62 v(out_n)=0.62 v(vbias)=0.5

.control
    op
    let iref = abs(@m.xm7.msky130_fd_pr__pfet_01v8[id]) * 1e9
    let i1 = abs(@m.xm1.msky130_fd_pr__nfet_01v8[id]) * 1e9
    let i2 = abs(@m.xm2.msky130_fd_pr__nfet_01v8[id]) * 1e9
    echo "=== R1=155k (l=21) ==="
    echo "Iref=$&iref nA  M1=$&i1 M2=$&i2"
    echo "nbias=$&v(nbias) out_n=$&v(out_n) src=$&v(src_m2)"
    let vov1 = @m.xm1.msky130_fd_pr__nfet_01v8[vgs] - @m.xm1.msky130_fd_pr__nfet_01v8[vth]
    echo "M1 Vov=$&vov1"

    ** Check if the OTA output mirror uses vbias correctly
    echo ""
    echo "=== Wait, M7 uses vbias gate (same as M3/M4) ==="
    echo "M7 should mirror M3/M4 current (NOT nbias-based)"
    echo "vbias = $&v(vbias)"
    let i3 = abs(@m.xm3.msky130_fd_pr__pfet_01v8[id]) * 1e9
    let i4 = abs(@m.xm4.msky130_fd_pr__pfet_01v8[id]) * 1e9
    echo "M3=$&i3 M4=$&i4 M7=$&iref"
    echo "M3 Vds=$&@m.xm3.msky130_fd_pr__pfet_01v8[vds]"
    echo "M4 Vds=$&@m.xm4.msky130_fd_pr__pfet_01v8[vds]"
    echo "M7 Vds=$&@m.xm7.msky130_fd_pr__pfet_01v8[vds]"
.endc

.end

** tb_diag.spice — Test if nodeset fixes convergence

.param mc_mm_switch=0
.param mc_pr_switch=0
.option scale=1e-6

.lib "/home/ubuntu/.volare/sky130A/libs.tech/combined/continuous/sky130.lib.spice" tt

XM3 nbias nbias vdd vdd sky130_fd_pr__pfet_01v8 w=1.5 l=4
XM4 out_n nbias vdd vdd sky130_fd_pr__pfet_01v8 w=1.5 l=4
XM1 nbias nbias 0 0 sky130_fd_pr__nfet_01v8 w=2 l=4
XM2 out_n nbias src_m2 0 sky130_fd_pr__nfet_01v8 w=8 l=4
XR1 src_m2 0 0 sky130_fd_pr__res_xhigh_po w=0.35 l=21

XM7 iref_out nbias vdd vdd sky130_fd_pr__pfet_01v8 w=1.5 l=4
Vload iref_out 0 0.9

Vdd vdd 0 1.8
** Force out_n to mid-range where both M4 and M2 should be in saturation
.nodeset v(nbias)=0.62 v(out_n)=0.5

.control
    op
    echo "=== VDD=1.8V with nodeset out_n=0.5 ==="
    let iref = abs(@m.xm7.msky130_fd_pr__pfet_01v8[id]) * 1e9
    echo "Iref = $&iref nA"
    echo "nbias = $&v(nbias)"
    echo "out_n = $&v(out_n)"
    echo "src_m2 = $&v(src_m2)"
    echo "M4_Vds = $&@m.xm4.msky130_fd_pr__pfet_01v8[vds]"
    let pmos_od = abs(@m.xm3.msky130_fd_pr__pfet_01v8[vgs]) - abs(@m.xm3.msky130_fd_pr__pfet_01v8[vth])
    echo "PMOS_od = $&pmos_od"
    let m1_id = @m.xm1.msky130_fd_pr__nfet_01v8[id] * 1e9
    let m2_id = @m.xm2.msky130_fd_pr__nfet_01v8[id] * 1e9
    let m4_id = abs(@m.xm4.msky130_fd_pr__pfet_01v8[id]) * 1e9
    echo "M1_id = $&m1_id nA  M2_id = $&m2_id nA  M4_id = $&m4_id nA"
    echo ""

    ** Now try sweeping with nodeset each time
    foreach vdd_val 1.6 1.7 1.8 1.9 2.0
        alter Vdd = $vdd_val
        ** Reset nodesets - use save/load trick
        op
        let iref_v = abs(@m.xm7.msky130_fd_pr__pfet_01v8[id]) * 1e9
        let nb = v(nbias)
        let on = v(out_n)
        let sm2 = v(src_m2)
        let m4vds = @m.xm4.msky130_fd_pr__pfet_01v8[vds]
        let m1i = @m.xm1.msky130_fd_pr__nfet_01v8[id] * 1e9
        let m2i = @m.xm2.msky130_fd_pr__nfet_01v8[id] * 1e9
        echo "VDD=$vdd_val: Iref=$&iref_v nA  nbias=$&nb  out_n=$&on  src_m2=$&sm2  M4_Vds=$&m4vds  M1=$&m1i  M2=$&m2i"
    end
.endc

.end

** Quick R1 sensitivity test — does R1 actually control the current?

.param mc_mm_switch=0
.param mc_pr_switch=0
.option scale=1e-6

.lib "/home/ubuntu/.volare/sky130A/libs.tech/combined/continuous/sky130.lib.spice" tt

** Standard PMOS W=1.5 L=4, NMOS M1=2/4 M2=8/4
** Test R1 = 40k, 80k, 155k, 300k
.subckt bm vdd nbias out_n iref_out rval=21
XM3 nbias nbias vdd vdd sky130_fd_pr__pfet_01v8 w=1.5 l=4
XM4 out_n nbias vdd vdd sky130_fd_pr__pfet_01v8 w=1.5 l=4
XM1 nbias nbias 0 0 sky130_fd_pr__nfet_01v8 w=2 l=4
XM2 out_n nbias src_m2 0 sky130_fd_pr__nfet_01v8 w=8 l=4
XR1 src_m2 0 0 sky130_fd_pr__res_xhigh_po w=0.35 l=rval
XM7 iref_out nbias vdd vdd sky130_fd_pr__pfet_01v8 w=1.5 l=4
.ends

Xa vdd nba outa irefa bm rval=5.6
VLa irefa 0 0.9

Xb vdd nbb outb irefb bm rval=10.5
VLb irefb 0 0.9

Xc vdd nbc outc irefc bm rval=21
VLc irefc 0 0.9

Xd vdd nbd outd irefd bm rval=42
VLd irefd 0 0.9

Vdd vdd 0 1.8
.nodeset v(nba)=0.62 v(nbb)=0.62 v(nbc)=0.62 v(nbd)=0.62

.control
    op
    echo "R1=40k:  Iref = $&@m.xa.xm7.msky130_fd_pr__pfet_01v8[id]"
    echo "R1=77k:  Iref = $&@m.xb.xm7.msky130_fd_pr__pfet_01v8[id]"
    echo "R1=155k: Iref = $&@m.xc.xm7.msky130_fd_pr__pfet_01v8[id]"
    echo "R1=310k: Iref = $&@m.xd.xm7.msky130_fd_pr__pfet_01v8[id]"
.endc

.end

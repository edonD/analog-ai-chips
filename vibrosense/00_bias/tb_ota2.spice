** tb_ota2.spice — OTA beta-mult: R1 sweep + TC optimization
** Verify R1 regulation, then optimize for TC < 150 ppm/C

.param mc_mm_switch=0
.param mc_pr_switch=0
.option scale=1e-6

.lib "/home/ubuntu/.volare/sky130A/libs.tech/combined/continuous/sky130.lib.spice" tt

** ===== Config A: R1=155k (l=21) baseline =====
XM3a nba vba vdd vdd sky130_fd_pr__pfet_01v8 w=4 l=4
XM4a outa vba vdd vdd sky130_fd_pr__pfet_01v8 w=4 l=4
XM1a nba nba 0 0 sky130_fd_pr__nfet_01v8 w=2 l=4
XM2a outa nba s2a 0 sky130_fd_pr__nfet_01v8 w=8 l=4
XR1a s2a 0 0 sky130_fd_pr__res_xhigh_po w=0.35 l=21
XMo1a od1a nba ota 0 sky130_fd_pr__nfet_01v8 w=1 l=4
XMo2a vba outa ota 0 sky130_fd_pr__nfet_01v8 w=1 l=4
XMo3a od1a od1a vdd vdd sky130_fd_pr__pfet_01v8 w=2 l=4
XMo4a vba od1a vdd vdd sky130_fd_pr__pfet_01v8 w=2 l=4
XMo5a ota nba 0 0 sky130_fd_pr__nfet_01v8 w=0.5 l=8
XM7a ia nba vdd vdd sky130_fd_pr__pfet_01v8 w=4 l=4
VLa ia 0 0.9

** ===== Config B: R1=310k (l=42) — should give ~half current =====
XM3b nbb vbb vdd vdd sky130_fd_pr__pfet_01v8 w=4 l=4
XM4b outb vbb vdd vdd sky130_fd_pr__pfet_01v8 w=4 l=4
XM1b nbb nbb 0 0 sky130_fd_pr__nfet_01v8 w=2 l=4
XM2b outb nbb s2b 0 sky130_fd_pr__nfet_01v8 w=8 l=4
XR1b s2b 0 0 sky130_fd_pr__res_xhigh_po w=0.35 l=42
XMo1b od1b nbb otb 0 sky130_fd_pr__nfet_01v8 w=1 l=4
XMo2b vbb outb otb 0 sky130_fd_pr__nfet_01v8 w=1 l=4
XMo3b od1b od1b vdd vdd sky130_fd_pr__pfet_01v8 w=2 l=4
XMo4b vbb od1b vdd vdd sky130_fd_pr__pfet_01v8 w=2 l=4
XMo5b otb nbb 0 0 sky130_fd_pr__nfet_01v8 w=0.5 l=8
XM7b ib nbb vdd vdd sky130_fd_pr__pfet_01v8 w=4 l=4
VLb ib 0 0.9

** ===== Config C: R1=77k (l=10.5) — should give ~double current =====
XM3c nbc vbc vdd vdd sky130_fd_pr__pfet_01v8 w=4 l=4
XM4c outc vbc vdd vdd sky130_fd_pr__pfet_01v8 w=4 l=4
XM1c nbc nbc 0 0 sky130_fd_pr__nfet_01v8 w=2 l=4
XM2c outc nbc s2c 0 sky130_fd_pr__nfet_01v8 w=8 l=4
XR1c s2c 0 0 sky130_fd_pr__res_xhigh_po w=0.35 l=10.5
XMo1c od1c nbc otc 0 sky130_fd_pr__nfet_01v8 w=1 l=4
XMo2c vbc outc otc 0 sky130_fd_pr__nfet_01v8 w=1 l=4
XMo3c od1c od1c vdd vdd sky130_fd_pr__pfet_01v8 w=2 l=4
XMo4c vbc od1c vdd vdd sky130_fd_pr__pfet_01v8 w=2 l=4
XMo5c otc nbc 0 0 sky130_fd_pr__nfet_01v8 w=0.5 l=8
XM7c ic nbc vdd vdd sky130_fd_pr__pfet_01v8 w=4 l=4
VLc ic 0 0.9

** ===== Config D: Different NMOS sizing M1=1/4 M2=4/4 K=4 =====
** Smaller M1 → higher Vov → closer to ZTC point
XM3d nbd vbd vdd vdd sky130_fd_pr__pfet_01v8 w=4 l=4
XM4d outd vbd vdd vdd sky130_fd_pr__pfet_01v8 w=4 l=4
XM1d nbd nbd 0 0 sky130_fd_pr__nfet_01v8 w=1 l=4
XM2d outd nbd s2d 0 sky130_fd_pr__nfet_01v8 w=4 l=4
XR1d s2d 0 0 sky130_fd_pr__res_xhigh_po w=0.35 l=21
XMo1d od1d nbd otd 0 sky130_fd_pr__nfet_01v8 w=1 l=4
XMo2d vbd outd otd 0 sky130_fd_pr__nfet_01v8 w=1 l=4
XMo3d od1d od1d vdd vdd sky130_fd_pr__pfet_01v8 w=2 l=4
XMo4d vbd od1d vdd vdd sky130_fd_pr__pfet_01v8 w=2 l=4
XMo5d otd nbd 0 0 sky130_fd_pr__nfet_01v8 w=0.5 l=8
XM7d id_out nbd vdd vdd sky130_fd_pr__pfet_01v8 w=4 l=4
VLd id_out 0 0.9

** ===== Config E: M1=0.5/4 M2=2/4 K=4 (even smaller M1) =====
XM3e nbe vbe vdd vdd sky130_fd_pr__pfet_01v8 w=4 l=4
XM4e oute vbe vdd vdd sky130_fd_pr__pfet_01v8 w=4 l=4
XM1e nbe nbe 0 0 sky130_fd_pr__nfet_01v8 w=0.5 l=4
XM2e oute nbe s2e 0 sky130_fd_pr__nfet_01v8 w=2 l=4
XR1e s2e 0 0 sky130_fd_pr__res_xhigh_po w=0.35 l=21
XMo1e od1e nbe ote 0 sky130_fd_pr__nfet_01v8 w=1 l=4
XMo2e vbe oute ote 0 sky130_fd_pr__nfet_01v8 w=1 l=4
XMo3e od1e od1e vdd vdd sky130_fd_pr__pfet_01v8 w=2 l=4
XMo4e vbe od1e vdd vdd sky130_fd_pr__pfet_01v8 w=2 l=4
XMo5e ote nbe 0 0 sky130_fd_pr__nfet_01v8 w=0.5 l=8
XM7e ie nbe vdd vdd sky130_fd_pr__pfet_01v8 w=4 l=4
VLe ie 0 0.9

Vdd vdd 0 1.8
.nodeset v(nba)=0.62 v(nbb)=0.62 v(nbc)=0.62 v(nbd)=0.62 v(nbe)=0.62 v(outa)=0.62 v(outb)=0.62 v(outc)=0.62 v(outd)=0.62 v(oute)=0.62

.control
    ** DC operating point at 27C
    op
    echo "=== DC Operating Point (27C) ==="
    let ia = abs(@m.xm7a.msky130_fd_pr__pfet_01v8[id]) * 1e9
    let ib = abs(@m.xm7b.msky130_fd_pr__pfet_01v8[id]) * 1e9
    let ic = abs(@m.xm7c.msky130_fd_pr__pfet_01v8[id]) * 1e9
    let id_v = abs(@m.xm7d.msky130_fd_pr__pfet_01v8[id]) * 1e9
    let ie = abs(@m.xm7e.msky130_fd_pr__pfet_01v8[id]) * 1e9
    echo "A (R1=155k, M1=2/4): Iref=$&ia nA"
    echo "B (R1=310k, M1=2/4): Iref=$&ib nA"
    echo "C (R1=77k,  M1=2/4): Iref=$&ic nA"
    echo "D (R1=155k, M1=1/4): Iref=$&id_v nA"
    echo "E (R1=155k, M1=.5/4): Iref=$&ie nA"

    let vov_a = @m.xm1a.msky130_fd_pr__nfet_01v8[vgs] - @m.xm1a.msky130_fd_pr__nfet_01v8[vth]
    let vov_d = @m.xm1d.msky130_fd_pr__nfet_01v8[vgs] - @m.xm1d.msky130_fd_pr__nfet_01v8[vth]
    let vov_e = @m.xm1e.msky130_fd_pr__nfet_01v8[vgs] - @m.xm1e.msky130_fd_pr__nfet_01v8[vth]
    echo "M1 Vov: A=$&vov_a  D=$&vov_d  E=$&vov_e"

    ** Temperature sweep for each config
    echo ""
    echo "=== Temperature Sweep ==="

    set temp = -40
    op
    let am40 = abs(@m.xm7a.msky130_fd_pr__pfet_01v8[id]) * 1e9
    let dm40 = abs(@m.xm7d.msky130_fd_pr__pfet_01v8[id]) * 1e9
    let em40 = abs(@m.xm7e.msky130_fd_pr__pfet_01v8[id]) * 1e9
    echo "T=-40: A=$&am40 D=$&dm40 E=$&em40 nA"

    set temp = 0
    op
    let a0 = abs(@m.xm7a.msky130_fd_pr__pfet_01v8[id]) * 1e9
    let d0 = abs(@m.xm7d.msky130_fd_pr__pfet_01v8[id]) * 1e9
    let e0 = abs(@m.xm7e.msky130_fd_pr__pfet_01v8[id]) * 1e9
    echo "T=0:   A=$&a0 D=$&d0 E=$&e0 nA"

    set temp = 27
    op
    let a27 = abs(@m.xm7a.msky130_fd_pr__pfet_01v8[id]) * 1e9
    let d27 = abs(@m.xm7d.msky130_fd_pr__pfet_01v8[id]) * 1e9
    let e27 = abs(@m.xm7e.msky130_fd_pr__pfet_01v8[id]) * 1e9
    echo "T=27:  A=$&a27 D=$&d27 E=$&e27 nA"

    set temp = 60
    op
    let a60 = abs(@m.xm7a.msky130_fd_pr__pfet_01v8[id]) * 1e9
    let d60 = abs(@m.xm7d.msky130_fd_pr__pfet_01v8[id]) * 1e9
    let e60 = abs(@m.xm7e.msky130_fd_pr__pfet_01v8[id]) * 1e9
    echo "T=60:  A=$&a60 D=$&d60 E=$&e60 nA"

    set temp = 85
    op
    let a85 = abs(@m.xm7a.msky130_fd_pr__pfet_01v8[id]) * 1e9
    let d85 = abs(@m.xm7d.msky130_fd_pr__pfet_01v8[id]) * 1e9
    let e85 = abs(@m.xm7e.msky130_fd_pr__pfet_01v8[id]) * 1e9
    echo "T=85:  A=$&a85 D=$&d85 E=$&e85 nA"

    let tc_a = abs(a85 - am40) / a27 / 125 * 1e6
    let tc_d = abs(d85 - dm40) / d27 / 125 * 1e6
    let tc_e = abs(e85 - em40) / e27 / 125 * 1e6
    echo ""
    echo "TC_A (M1=2/4 R1=155k) = $&tc_a ppm/C"
    echo "TC_D (M1=1/4 R1=155k) = $&tc_d ppm/C"
    echo "TC_E (M1=.5/4 R1=155k) = $&tc_e ppm/C"
.endc

.end

** tb_full.spice — Full verification, inline core circuit

.param mc_mm_switch=0
.param mc_pr_switch=0
.option scale=1e-6

.lib "/home/ubuntu/.volare/sky130A/libs.tech/combined/continuous/sky130.lib.spice" tt

** Core beta-multiplier (no startup devices)
XM3 nbias nbias vdd vdd sky130_fd_pr__pfet_01v8 w=1.5 l=4
XM4 out_n nbias vdd vdd sky130_fd_pr__pfet_01v8 w=1.5 l=4
XM1 nbias nbias 0 0 sky130_fd_pr__nfet_01v8 w=2 l=4
XM2 out_n nbias src_m2 0 sky130_fd_pr__nfet_01v8 w=8 l=4
XR1 src_m2 0 0 sky130_fd_pr__res_xhigh_po w=0.35 l=21
XM7 iref_out nbias vdd vdd sky130_fd_pr__pfet_01v8 w=1.5 l=4
Vload iref_out 0 0.9

Vdd vdd 0 1.8
.nodeset v(nbias)=0.62

.control
    ** ===== Test 1: DC Operating Point =====
    op
    echo "=========================================="
    echo "=== TEST 1: DC Operating Point (TT/27C/1.8V) ==="
    echo "=========================================="
    echo "nbias = $&v(nbias)"
    echo "out_n = $&v(out_n)"
    echo "src_m2 = $&v(src_m2)"
    let iref = abs(@m.xm7.msky130_fd_pr__pfet_01v8[id])
    let iref_na = iref * 1e9
    echo "Iref = $&iref_na nA"
    let pmos_od = abs(@m.xm3.msky130_fd_pr__pfet_01v8[vgs]) - abs(@m.xm3.msky130_fd_pr__pfet_01v8[vth])
    echo "PMOS_od = $&pmos_od V"
    echo "M4_Vds = $&@m.xm4.msky130_fd_pr__pfet_01v8[vds]"
    let power = abs(i(Vdd)) * 1.8
    let power_uw = power * 1e6
    echo "Power = $&power_uw uW"

    ** ===== Test 2: Temperature Sweep =====
    echo ""
    echo "=========================================="
    echo "=== TEST 2: Temperature Sweep ==="
    echo "=========================================="

    let temps = ( -40 -20 0 20 27 40 60 85 )
    let iref_t = vector(8)
    let idx = 0

    foreach temp_val $&temps
        set temp = $temp_val
        op
        let iref_t[idx] = abs(@m.xm7.msky130_fd_pr__pfet_01v8[id])
        let iref_na_t = iref_t[idx] * 1e9
        echo "T=$temp_val C  Iref=$&iref_na_t nA"
        let idx = idx + 1
    end

    let iref_min = minimum(iref_t)
    let iref_max = maximum(iref_t)
    let iref_nom = iref_t[4]
    let tc_ppm = (iref_max - iref_min) / iref_nom / 125 * 1e6
    let iref_min_na = iref_min * 1e9
    let iref_max_na = iref_max * 1e9
    let iref_nom_na = iref_nom * 1e9
    echo ""
    echo ">>> Iref range: $&iref_min_na to $&iref_max_na nA"
    echo ">>> TC = $&tc_ppm ppm/C"

    ** ===== Test 3: Supply Sweep =====
    echo ""
    echo "=========================================="
    echo "=== TEST 3: Supply Sensitivity ==="
    echo "=========================================="

    set temp = 27
    foreach vdd_val 1.4 1.5 1.6 1.7 1.8 1.9 2.0 2.1 2.2
        alter Vdd = $vdd_val
        op
        let iref_v = abs(@m.xm7.msky130_fd_pr__pfet_01v8[id]) * 1e9
        echo "VDD=$vdd_val V  Iref=$&iref_v nA"
    end

    alter Vdd = 1.6
    op
    let iref_1p6 = abs(@m.xm7.msky130_fd_pr__pfet_01v8[id])
    alter Vdd = 1.8
    op
    let iref_1p8 = abs(@m.xm7.msky130_fd_pr__pfet_01v8[id])
    alter Vdd = 2.0
    op
    let iref_2p0 = abs(@m.xm7.msky130_fd_pr__pfet_01v8[id])

    let supply_sens = abs(iref_2p0 - iref_1p6) / iref_1p8 / 0.4 * 100
    echo ""
    echo ">>> Supply sensitivity = $&supply_sens %/V"
.endc

.end

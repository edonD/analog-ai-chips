** tb_ota.spice — OTA-regulated beta-multiplier
** 5-transistor OTA forces V(out_n) = V(nbias)
** This gives M2 saturation + high supply rejection

.param mc_mm_switch=0
.param mc_pr_switch=0
.option scale=1e-6

.lib "/home/ubuntu/.volare/sky130A/libs.tech/combined/continuous/sky130.lib.spice" tt

** ===== Main PMOS mirror (gate = vbias from OTA) =====
XM3 nbias vbias vdd vdd sky130_fd_pr__pfet_01v8 w=4 l=4
XM4 out_n vbias vdd vdd sky130_fd_pr__pfet_01v8 w=4 l=4

** ===== NMOS pair (standard beta-multiplier) =====
XM1 nbias nbias 0 0 sky130_fd_pr__nfet_01v8 w=2 l=4
XM2 out_n nbias src_m2 0 sky130_fd_pr__nfet_01v8 w=8 l=4
XR1 src_m2 0 0 sky130_fd_pr__res_xhigh_po w=0.35 l=21

** ===== OTA: forces V(out_n) = V(nbias) =====
** NMOS diff pair: + = nbias, - = out_n
XMo1 od1 nbias otail 0 sky130_fd_pr__nfet_01v8 w=1 l=4
XMo2 vbias out_n otail 0 sky130_fd_pr__nfet_01v8 w=1 l=4
** PMOS active load (diode + mirror)
XMo3 od1 od1 vdd vdd sky130_fd_pr__pfet_01v8 w=2 l=4
XMo4 vbias od1 vdd vdd sky130_fd_pr__pfet_01v8 w=2 l=4
** NMOS tail current source (biased by nbias)
XMo5 otail nbias 0 0 sky130_fd_pr__nfet_01v8 w=0.5 l=8

** ===== Output mirror =====
XM7 iref_out vbias vdd vdd sky130_fd_pr__pfet_01v8 w=4 l=4
Vload iref_out 0 0.9

Vdd vdd 0 1.8
.nodeset v(nbias)=0.62 v(out_n)=0.62 v(vbias)=0.5

.control
    op
    echo "==========================================="
    echo "=== DC Operating Point ==="
    echo "==========================================="
    let iref = abs(@m.xm7.msky130_fd_pr__pfet_01v8[id]) * 1e9
    echo "Iref = $&iref nA"
    echo "nbias = $&v(nbias)"
    echo "out_n = $&v(out_n)"
    echo "vbias = $&v(vbias)"
    echo "src_m2 = $&v(src_m2)"
    echo "od1 = $&v(od1)"
    echo "otail = $&v(otail)"

    let i1 = abs(@m.xm1.msky130_fd_pr__nfet_01v8[id]) * 1e9
    let i2 = abs(@m.xm2.msky130_fd_pr__nfet_01v8[id]) * 1e9
    echo "M1 Id = $&i1 nA"
    echo "M2 Id = $&i2 nA"

    echo ""
    echo "--- Saturation checks ---"
    echo "M2 Vds = $&@m.xm2.msky130_fd_pr__nfet_01v8[vds]"
    let vov2 = @m.xm2.msky130_fd_pr__nfet_01v8[vgs] - @m.xm2.msky130_fd_pr__nfet_01v8[vth]
    echo "M2 Vov = $&vov2"
    let sat2 = @m.xm2.msky130_fd_pr__nfet_01v8[vds] - vov2
    echo "M2 sat margin = $&sat2 (must be > 0)"
    echo "M3 Vds = $&@m.xm3.msky130_fd_pr__pfet_01v8[vds]"
    echo "M4 Vds = $&@m.xm4.msky130_fd_pr__pfet_01v8[vds]"
    let pov = abs(@m.xm3.msky130_fd_pr__pfet_01v8[vgs]) - abs(@m.xm3.msky130_fd_pr__pfet_01v8[vth])
    echo "PMOS Vov = $&pov"
    echo "M1 Vds = $&@m.xm1.msky130_fd_pr__nfet_01v8[vds]"

    let power = abs(i(Vdd)) * 1.8 * 1e6
    echo "Power = $&power uW"

    echo ""
    echo "--- OTA operating point ---"
    let imo5 = abs(@m.xmo5.msky130_fd_pr__nfet_01v8[id]) * 1e9
    echo "OTA tail current = $&imo5 nA"

    ** ===== VDD Sweep =====
    echo ""
    echo "==========================================="
    echo "=== VDD Sweep ==="
    echo "==========================================="
    foreach vdd_val 1.2 1.3 1.4 1.5 1.6 1.7 1.8 1.9 2.0 2.1 2.2
        alter Vdd = $vdd_val
        op
        let iv = abs(@m.xm7.msky130_fd_pr__pfet_01v8[id]) * 1e9
        echo "VDD=$vdd_val Iref=$&iv nA nbias=$&v(nbias) out_n=$&v(out_n) vbias=$&v(vbias)"
    end

    ** Supply sensitivity
    echo ""
    alter Vdd = 1.6
    op
    let i16 = abs(@m.xm7.msky130_fd_pr__pfet_01v8[id])
    alter Vdd = 1.8
    op
    let i18 = abs(@m.xm7.msky130_fd_pr__pfet_01v8[id])
    alter Vdd = 2.0
    op
    let i20 = abs(@m.xm7.msky130_fd_pr__pfet_01v8[id])
    let ss = abs(i20 - i16) / i18 / 0.4 * 100
    let i16n = i16 * 1e9
    let i18n = i18 * 1e9
    let i20n = i20 * 1e9
    echo ">>> Supply Sensitivity:"
    echo "I@1.6V = $&i16n nA"
    echo "I@1.8V = $&i18n nA"
    echo "I@2.0V = $&i20n nA"
    echo "SS = $&ss %/V"

    ** ===== Temperature Sweep =====
    echo ""
    echo "==========================================="
    echo "=== Temperature Sweep ==="
    echo "==========================================="
    alter Vdd = 1.8
    set temp = -40
    op
    let im40 = abs(@m.xm7.msky130_fd_pr__pfet_01v8[id]) * 1e9
    echo "T=-40C Iref=$&im40 nA"
    set temp = 0
    op
    let i0 = abs(@m.xm7.msky130_fd_pr__pfet_01v8[id]) * 1e9
    echo "T=0C Iref=$&i0 nA"
    set temp = 27
    op
    let i27 = abs(@m.xm7.msky130_fd_pr__pfet_01v8[id]) * 1e9
    echo "T=27C Iref=$&i27 nA"
    set temp = 60
    op
    let i60 = abs(@m.xm7.msky130_fd_pr__pfet_01v8[id]) * 1e9
    echo "T=60C Iref=$&i60 nA"
    set temp = 85
    op
    let i85 = abs(@m.xm7.msky130_fd_pr__pfet_01v8[id]) * 1e9
    echo "T=85C Iref=$&i85 nA"
    let tc = abs(i85 - im40) / i27 / 125 * 1e6
    echo "TC = $&tc ppm/C"

    ** R1 sensitivity
    echo ""
    echo "=== R1 sensitivity check ==="
    echo "Baseline Iref at VDD=1.8V, T=27C shown above"
    echo "If R1 matters, current should change with R1 value"
.endc

.end

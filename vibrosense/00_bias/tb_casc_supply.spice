** tb_casc_supply.spice — Standard PMOS cascode on both branches
** M5a/M5b (std PMOS) shield M3/M4 (LVT PMOS) from VDD changes
** Using Widlar variant: R1 on M1 (wider), M2 narrower

.param mc_mm_switch=0
.param mc_pr_switch=0
.option scale=1e-6

.lib "/home/ubuntu/.volare/sky130A/libs.tech/combined/continuous/sky130.lib.spice" tt

** ===== Config A: Both branches cascoded =====
** Input branch cascode
XM5a lv3a nbias vdd vdd sky130_fd_pr__pfet_01v8 w=4 l=4
XM3a nbias nbias lv3a vdd sky130_fd_pr__pfet_01v8_lvt w=0.42 l=8
** Output branch cascode
XM5b lv4a nbias vdd vdd sky130_fd_pr__pfet_01v8 w=4 l=4
XM4a out_a nbias lv4a vdd sky130_fd_pr__pfet_01v8_lvt w=0.42 l=8
** NMOS Widlar: M1 wider with R1, M2 narrower
XM1a nbias nbias srca 0 sky130_fd_pr__nfet_01v8 w=4 l=8
XR1a srca 0 0 sky130_fd_pr__res_xhigh_po w=0.35 l=21
XM2a out_a nbias 0 0 sky130_fd_pr__nfet_01v8 w=1 l=8
** Output mirror (with cascode)
XM5c lv7a nbias vdd vdd sky130_fd_pr__pfet_01v8 w=4 l=4
XM7a iref_a nbias lv7a vdd sky130_fd_pr__pfet_01v8_lvt w=0.42 l=8
VLa iref_a 0 0.9

** ===== Config B: Same but standard beta-mult (R1 on M2) =====
XM5d lv3b nbb vdd vdd sky130_fd_pr__pfet_01v8 w=4 l=4
XM3b nbb nbb lv3b vdd sky130_fd_pr__pfet_01v8_lvt w=0.42 l=8
XM5e lv4b nbb vdd vdd sky130_fd_pr__pfet_01v8 w=4 l=4
XM4b out_b nbb lv4b vdd sky130_fd_pr__pfet_01v8_lvt w=0.42 l=8
XM1b nbb nbb 0 0 sky130_fd_pr__nfet_01v8 w=1 l=8
XM2b out_b nbb srcb 0 sky130_fd_pr__nfet_01v8 w=4 l=8
XR1b srcb 0 0 sky130_fd_pr__res_xhigh_po w=0.35 l=21
XM5f lv7b nbb vdd vdd sky130_fd_pr__pfet_01v8 w=4 l=4
XM7b iref_b nbb lv7b vdd sky130_fd_pr__pfet_01v8_lvt w=0.42 l=8
VLb iref_b 0 0.9

** ===== Config C: Widlar, no cascode (baseline) =====
XM3c nbc nbc vdd vdd sky130_fd_pr__pfet_01v8_lvt w=0.42 l=8
XM4c out_c nbc vdd vdd sky130_fd_pr__pfet_01v8_lvt w=0.42 l=8
XM1c nbc nbc srcc 0 sky130_fd_pr__nfet_01v8 w=4 l=8
XR1c srcc 0 0 sky130_fd_pr__res_xhigh_po w=0.35 l=21
XM2c out_c nbc 0 0 sky130_fd_pr__nfet_01v8 w=1 l=8
XM7c iref_c nbc vdd vdd sky130_fd_pr__pfet_01v8_lvt w=0.42 l=8
VLc iref_c 0 0.9

Vdd vdd 0 1.8
.nodeset v(nbias)=0.7 v(nbb)=0.62 v(nbc)=0.7

.control
    op
    echo "=== DC Operating Point ==="
    echo ""
    echo "--- Config A: Widlar + cascode ---"
    let ia = abs(@m.xm7a.msky130_fd_pr__pfet_01v8_lvt[id]) * 1e9
    echo "Iref = $&ia nA"
    echo "nbias=$&v(nbias) out_n=$&v(out_a) lv3=$&v(lv3a) lv4=$&v(lv4a) src=$&v(srca)"
    echo "M5a_Vds=$&@m.xm5a.msky130_fd_pr__pfet_01v8[vds]"
    echo "M3_Vds=$&@m.xm3a.msky130_fd_pr__pfet_01v8_lvt[vds]"
    echo "M4_Vds=$&@m.xm4a.msky130_fd_pr__pfet_01v8_lvt[vds]"
    echo "M2_Vds=$&@m.xm2a.msky130_fd_pr__nfet_01v8[vds]"
    let vov2a = @m.xm2a.msky130_fd_pr__nfet_01v8[vgs] - @m.xm2a.msky130_fd_pr__nfet_01v8[vth]
    echo "M2_Vov=$&vov2a"
    let i1a = abs(@m.xm1a.msky130_fd_pr__nfet_01v8[id]) * 1e9
    let i2a = abs(@m.xm2a.msky130_fd_pr__nfet_01v8[id]) * 1e9
    echo "M1=$&i1a M2=$&i2a"

    echo ""
    echo "--- Config B: Standard + cascode ---"
    let ib = abs(@m.xm7b.msky130_fd_pr__pfet_01v8_lvt[id]) * 1e9
    echo "Iref = $&ib nA"
    echo "nbb=$&v(nbb) out_b=$&v(out_b) src=$&v(srcb)"
    echo "M2b_Vds=$&@m.xm2b.msky130_fd_pr__nfet_01v8[vds]"

    echo ""
    echo "--- Config C: Widlar no cascode ---"
    let ic = abs(@m.xm7c.msky130_fd_pr__pfet_01v8_lvt[id]) * 1e9
    echo "Iref = $&ic nA"
    echo "nbc=$&v(nbc) out_c=$&v(out_c)"

    ** ===== VDD Sweep =====
    echo ""
    echo "=== VDD Sweep ==="
    foreach vdd_val 1.4 1.5 1.6 1.7 1.8 1.9 2.0 2.1 2.2
        alter Vdd = $vdd_val
        op
        let iva = abs(@m.xm7a.msky130_fd_pr__pfet_01v8_lvt[id]) * 1e9
        let ivb = abs(@m.xm7b.msky130_fd_pr__pfet_01v8_lvt[id]) * 1e9
        let ivc = abs(@m.xm7c.msky130_fd_pr__pfet_01v8_lvt[id]) * 1e9
        echo "VDD=$vdd_val  A=$&iva  B=$&ivb  C=$&ivc nA"
    end

    ** Supply sensitivity
    echo ""
    echo "=== Supply Sensitivity ==="
    alter Vdd = 1.6
    op
    let ia16 = abs(@m.xm7a.msky130_fd_pr__pfet_01v8_lvt[id])
    let ib16 = abs(@m.xm7b.msky130_fd_pr__pfet_01v8_lvt[id])
    let ic16 = abs(@m.xm7c.msky130_fd_pr__pfet_01v8_lvt[id])
    alter Vdd = 1.8
    op
    let ia18 = abs(@m.xm7a.msky130_fd_pr__pfet_01v8_lvt[id])
    let ib18 = abs(@m.xm7b.msky130_fd_pr__pfet_01v8_lvt[id])
    let ic18 = abs(@m.xm7c.msky130_fd_pr__pfet_01v8_lvt[id])
    alter Vdd = 2.0
    op
    let ia20 = abs(@m.xm7a.msky130_fd_pr__pfet_01v8_lvt[id])
    let ib20 = abs(@m.xm7b.msky130_fd_pr__pfet_01v8_lvt[id])
    let ic20 = abs(@m.xm7c.msky130_fd_pr__pfet_01v8_lvt[id])

    let ssa = abs(ia20 - ia16) / ia18 / 0.4 * 100
    let ssb = abs(ib20 - ib16) / ib18 / 0.4 * 100
    let ssc = abs(ic20 - ic16) / ic18 / 0.4 * 100
    echo "Config A (Widlar+cascode): $&ssa %/V"
    echo "Config B (Std+cascode):    $&ssb %/V"
    echo "Config C (Widlar, no casc): $&ssc %/V"

    let ia16n = ia16 * 1e9
    let ia18n = ia18 * 1e9
    let ia20n = ia20 * 1e9
    echo "Config A: I@1.6=$&ia16n  I@1.8=$&ia18n  I@2.0=$&ia20n nA"
.endc

.end

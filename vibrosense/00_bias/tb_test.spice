** Test with regular lib and micron dimensions

.param mc_mm_switch=0
.param mc_pr_switch=0

.lib "/home/ubuntu/.volare/sky130A/libs.tech/ngspice/sky130.lib.spice" tt
.option scale=1e-6

XM1 d g vdd vdd sky130_fd_pr__pfet_01v8 w=8 l=1

Vdd vdd 0 1.8
Vg g 0 0.9
Vd d 0 0.9

.control
    op
    print @m.xm1.msky130_fd_pr__pfet_01v8[id]
    echo "test"
.endc

.end

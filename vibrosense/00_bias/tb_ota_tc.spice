** tb_ota_tc.spice — TC optimization with MOSFET resistor
** Add NMOS in triode (gate=VDD) in series with xhigh_po R1
** MOSFET resistance has +5000 ppm/C TC, compensating PTAT Vt

.param mc_mm_switch=0
.param mc_pr_switch=0
.option scale=1e-6

.lib "/home/ubuntu/.volare/sky130A/libs.tech/combined/continuous/sky130.lib.spice" tt

** ===== OTA-regulated beta-multiplier core =====
XM3 nbias vbias vdd vdd sky130_fd_pr__pfet_01v8 w=4 l=4
XM4 out_n vbias vdd vdd sky130_fd_pr__pfet_01v8 w=4 l=4
XM1 nbias nbias 0 0 sky130_fd_pr__nfet_01v8 w=2 l=4
XM2 out_n nbias src_m2 0 sky130_fd_pr__nfet_01v8 w=8 l=4

** R1: xhigh_po in series with NMOS triode resistor
** Rpoly: src_m2 → mid_r (fixed resistance, TC≈0)
** Mr1: mid_r → gnd (MOSFET resistance, TC≈5000 ppm/C)
** Adjusting Rpoly length and Mr1 W/L to tune total R and TC
XR1 src_m2 mid_r 0 sky130_fd_pr__res_xhigh_po w=0.35 l=10
XMr1 mid_r vdd 0 0 sky130_fd_pr__nfet_01v8 w=0.42 l=8

** OTA
XMo1 od1 nbias otail 0 sky130_fd_pr__nfet_01v8 w=1 l=4
XMo2 vbias out_n otail 0 sky130_fd_pr__nfet_01v8 w=1 l=4
XMo3 od1 od1 vdd vdd sky130_fd_pr__pfet_01v8 w=2 l=4
XMo4 vbias od1 vdd vdd sky130_fd_pr__pfet_01v8 w=2 l=4
XMo5 otail nbias 0 0 sky130_fd_pr__nfet_01v8 w=0.5 l=8

** Output mirror
XM7 iref_out vbias vdd vdd sky130_fd_pr__pfet_01v8 w=4 l=4
Vload iref_out 0 0.9

** Startup helper: weak pull-up to prevent zero-current state
XRstart vdd nbias 0 sky130_fd_pr__res_xhigh_po w=0.35 l=500

Vdd vdd 0 1.8
.nodeset v(nbias)=0.65 v(out_n)=0.65 v(vbias)=0.55 v(od1)=0.85

.control
    echo "=== DC Operating Point (27C) ==="
    set temp = 27
    op
    let iref = abs(@m.xm7.msky130_fd_pr__pfet_01v8[id]) * 1e9
    echo "Iref = $&iref nA"
    echo "nbias=$&v(nbias) out_n=$&v(out_n) src=$&v(src_m2) mid_r=$&v(mid_r)"
    let rmr1 = v(mid_r) / abs(@m.xmr1.msky130_fd_pr__nfet_01v8[id])
    let rmr1k = rmr1 / 1000
    echo "Mr1 resistance = $&rmr1k kohm"
    echo "Mr1 Vds=$&@m.xmr1.msky130_fd_pr__nfet_01v8[vds]"
    let vov_mr1 = @m.xmr1.msky130_fd_pr__nfet_01v8[vgs] - @m.xmr1.msky130_fd_pr__nfet_01v8[vth]
    echo "Mr1 Vov=$&vov_mr1 (should be >> Vds for triode)"

    echo ""
    echo "=== Temperature Sweep ==="
    foreach temp_val -40 -20 0 20 27 40 60 85
        set temp = $temp_val
        op
        let i = abs(@m.xm7.msky130_fd_pr__pfet_01v8[id]) * 1e9
        echo "T=$temp_val I=$&i nA"
    end

    echo ""
    echo "=== VDD Sweep ==="
    set temp = 27
    foreach vdd_val 1.6 1.8 2.0
        alter Vdd = $vdd_val
        op
        let i = abs(@m.xm7.msky130_fd_pr__pfet_01v8[id]) * 1e9
        echo "VDD=$vdd_val I=$&i nA"
    end
.endc

.end

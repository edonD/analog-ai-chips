* TB7: PGA Noise Analysis — Gain = 64x
* Measure input-referred noise spectral density
* PASS: < 200 nV/rtHz at 1 kHz

.option scale=1e-6
.lib "sky130_minimal.lib.spice" tt
.include "ota_behavioral.spice"
.include "pga.spice"

Vdd vdd 0 1.8
Vss vss 0 0
Vcm vcm 0 0.9
Vin vin 0 DC 0.9 AC 1
Vg1 g1 0 1.8
Vg0 g0 0 1.8
Xpga vin vout vcm vdd vss g1 g0 pga
CL vout 0 10p

.nodeset v(vout)=0.9 v(xpga.inn)=0.9 v(xpga.mid1)=0.9 v(xpga.mid2)=0.9 v(xpga.mid3)=0.9 v(xpga.mid4)=0.9

.control
* Run noise analysis
noise v(vout) Vin dec 100 1 1meg
setplot noise1
write tb_pga_noise.raw inoise_spectrum onoise_spectrum
echo "=== NOISE ANALYSIS COMPLETE ==="

* Note: behavioral OTA has no noise sources,
* so noise results reflect only switch thermal noise
* Real noise will be dominated by OTA devices
.endc

.end

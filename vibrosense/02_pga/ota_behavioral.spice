* Behavioral OTA for PGA development
* VCCS model: gm = 30 uS, Rout = 33 MOhm
* GBW ~ 480 kHz with 10 pF external load
* DC output biased at 0.9V, soft clamped to 0.05V..1.75V

.subckt ota_behavioral vip vim vout vdd vss
* Transconductance: gm = 30 uS, non-inverting
* (G n+ n- : positive current exits n+, so swap to get current INTO vout)
G1 vbias vout cur='30e-6 * (v(vip,vss) - v(vim,vss))'
* Output impedance biased at mid-rail
Rout vout vbias 33Meg
Vbias vbias vss 0.9
* Small internal cap
Cout vout vss 50f
* Soft output compliance: 1 S conductance beyond rail limits
* Prevents output from exceeding supply range
Bclamp vout vss I = {max(0, (V(vout,vss)-1.75)) * 1.0 + min(0, (V(vout,vss)-0.05)) * 1.0}
.ends ota_behavioral

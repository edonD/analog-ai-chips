* TB6: PGA Gain Switching Transient Response
* Vin = 1 kHz, 50 mVpk (constant)
* Gain steps: 1x → 4x → 16x → 64x → 1x at 1 ms intervals
* PASS: settling < 100 us, glitch < 50 mV

.option scale=1e-6
.lib "sky130_minimal.lib.spice" tt
.include "ota_behavioral.spice"
.include "pga.spice"

** Supply
Vdd vdd 0 1.8
Vss vss 0 0
Vcm vcm 0 0.9

** Input: 1 kHz, 10 mVpk (small enough for 64x gain to stay in range)
** Max output: 64 * 10mV = 640mVpk → 0.26V to 1.54V (within rails)
Vin vin 0 DC 0.9 SIN(0.9 0.01 1000)

** Gain select using PWL for stepped transitions
** g1 g0 → gain:  00=1x, 01=4x, 10=16x, 11=64x
** t=0-1ms:   1x  (g1=0, g0=0)
** t=1-2ms:   4x  (g1=0, g0=1.8)
** t=2-3ms:  16x  (g1=1.8, g0=0)
** t=3-4ms:  64x  (g1=1.8, g0=1.8)
** t=4-5ms:   1x  (g1=0, g0=0)

Vg1 g1 0 PWL(0 0  0.999m 0  1.001m 0  1.999m 0  2.001m 1.8  2.999m 1.8  3.001m 1.8  3.999m 1.8  4.001m 0)
Vg0 g0 0 PWL(0 0  0.999m 0  1.001m 1.8  1.999m 1.8  2.001m 0  2.999m 0  3.001m 1.8  3.999m 1.8  4.001m 0)

** PGA instance
Xpga vin vout vcm vdd vss g1 g0 pga

** Load capacitor
CL vout 0 10p

** Help DC OP convergence
.nodeset v(vout)=0.9 v(xpga.inn)=0.9 v(xpga.mid1)=0.9 v(xpga.mid2)=0.9 v(xpga.mid3)=0.9 v(xpga.mid4)=0.9

** Transient: 5 ms, step 100 ns
.tran 100n 5m

.control
run

write tb_pga_switching.raw v(vout) v(vin) v(g1) v(g0)
echo "=== SWITCHING COMPLETE ==="

* Measure settling and glitch at each transition
* Transition at t=1ms (1x→4x): output should go from ~50mVpk to ~200mVpk
meas tran vout_0p5m find v(vout) at=0.5m
meas tran vout_1p5m find v(vout) at=1.5m
meas tran vout_2p5m find v(vout) at=2.5m
meas tran vout_3p5m find v(vout) at=3.5m
meas tran vout_4p5m find v(vout) at=4.5m

* Peak output in each gain segment
meas tran peak_1x max v(vout) from=0.2m to=0.9m
meas tran peak_4x max v(vout) from=1.2m to=1.9m
meas tran peak_16x max v(vout) from=2.2m to=2.9m
meas tran peak_64x max v(vout) from=3.2m to=3.9m

echo ""
echo "--- Switching Results ---"
print peak_1x peak_4x peak_16x peak_64x
.endc

.end

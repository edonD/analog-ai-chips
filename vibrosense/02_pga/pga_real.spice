* VibroSense Block 02: Capacitive-Feedback PGA — Tapeout-Ready Version
* SKY130A Process
*
* All ideal components replaced with real silicon implementations:
*   - CMOS 2-to-4 decoder (replaces behavioral B-sources)
*   - MIM capacitors (replaces ideal C)
*   - PMOS pseudo-resistors (replaces ideal 10G resistors)
*
* Gain = Cin/Cf, switched by NMOS pass gates
* 4 gain settings: 1x (00), 4x (01), 16x (10), 64x (11)
*
* Topology: vin --[Cin_k]-- mid_k --[NMOS switch]-- inn --[Cf]-- vout
*
* Pinout: vin vout vcm vdd vss vbn vbcn vbp vbcp g1 g0
*   Bias pins (vbn, vbcn, vbp, vbcp) supplied externally from bias_generator_full
*
* Requires: ota_pga_v2 subcircuit defined before this file
* Requires: sky130_fd_pr__nfet_01v8 and sky130_fd_pr__pfet_01v8 models loaded
* Requires: sky130_fd_pr__cap_mim_m3_1 model loaded
* Use with: .option scale=1e-6

** ================================================================
** CMOS 2-TO-4 DECODER SUBCIRCUIT
** Inputs: g1, g0 (digital select bits)
** Outputs: sel0..sel3 (one-hot active-high)
** sel0 = ~g1 & ~g0   (gain 1x)
** sel1 = ~g1 &  g0   (gain 4x)
** sel2 =  g1 & ~g0   (gain 16x)
** sel3 =  g1 &  g0   (gain 64x)
** ================================================================
.subckt decoder_2to4 g1 g0 sel0 sel1 sel2 sel3 vdd vss

** --- Inverters for g1 and g0 ---
* INV g0 -> g0b
XP_inv0 g0b g0 vdd vdd sky130_fd_pr__pfet_01v8 w=0.84 l=0.15
XN_inv0 g0b g0 vss vss sky130_fd_pr__nfet_01v8 w=0.42 l=0.15

* INV g1 -> g1b
XP_inv1 g1b g1 vdd vdd sky130_fd_pr__pfet_01v8 w=0.84 l=0.15
XN_inv1 g1b g1 vss vss sky130_fd_pr__nfet_01v8 w=0.42 l=0.15

** --- NAND2 gates ---
* NAND2(g1b, g0b) -> nand0_out   (sel0 = ~g1 & ~g0)
XP_nand0a nand0_out g1b vdd vdd sky130_fd_pr__pfet_01v8 w=0.84 l=0.15
XP_nand0b nand0_out g0b vdd vdd sky130_fd_pr__pfet_01v8 w=0.84 l=0.15
XN_nand0a nand0_out g1b nand0_mid vss sky130_fd_pr__nfet_01v8 w=0.84 l=0.15
XN_nand0b nand0_mid g0b vss vss sky130_fd_pr__nfet_01v8 w=0.84 l=0.15

* NAND2(g1b, g0) -> nand1_out   (sel1 = ~g1 & g0)
XP_nand1a nand1_out g1b vdd vdd sky130_fd_pr__pfet_01v8 w=0.84 l=0.15
XP_nand1b nand1_out g0  vdd vdd sky130_fd_pr__pfet_01v8 w=0.84 l=0.15
XN_nand1a nand1_out g1b nand1_mid vss sky130_fd_pr__nfet_01v8 w=0.84 l=0.15
XN_nand1b nand1_mid g0  vss vss sky130_fd_pr__nfet_01v8 w=0.84 l=0.15

* NAND2(g1, g0b) -> nand2_out   (sel2 = g1 & ~g0)
XP_nand2a nand2_out g1  vdd vdd sky130_fd_pr__pfet_01v8 w=0.84 l=0.15
XP_nand2b nand2_out g0b vdd vdd sky130_fd_pr__pfet_01v8 w=0.84 l=0.15
XN_nand2a nand2_out g1  nand2_mid vss sky130_fd_pr__nfet_01v8 w=0.84 l=0.15
XN_nand2b nand2_mid g0b vss vss sky130_fd_pr__nfet_01v8 w=0.84 l=0.15

* NAND2(g1, g0) -> nand3_out    (sel3 = g1 & g0)
XP_nand3a nand3_out g1  vdd vdd sky130_fd_pr__pfet_01v8 w=0.84 l=0.15
XP_nand3b nand3_out g0  vdd vdd sky130_fd_pr__pfet_01v8 w=0.84 l=0.15
XN_nand3a nand3_out g1  nand3_mid vss sky130_fd_pr__nfet_01v8 w=0.84 l=0.15
XN_nand3b nand3_mid g0  vss vss sky130_fd_pr__nfet_01v8 w=0.84 l=0.15

** --- Output inverters (NAND outputs are active-low, invert for active-high) ---
XP_oinv0 sel0 nand0_out vdd vdd sky130_fd_pr__pfet_01v8 w=0.84 l=0.15
XN_oinv0 sel0 nand0_out vss vss sky130_fd_pr__nfet_01v8 w=0.42 l=0.15

XP_oinv1 sel1 nand1_out vdd vdd sky130_fd_pr__pfet_01v8 w=0.84 l=0.15
XN_oinv1 sel1 nand1_out vss vss sky130_fd_pr__nfet_01v8 w=0.42 l=0.15

XP_oinv2 sel2 nand2_out vdd vdd sky130_fd_pr__pfet_01v8 w=0.84 l=0.15
XN_oinv2 sel2 nand2_out vss vss sky130_fd_pr__nfet_01v8 w=0.42 l=0.15

XP_oinv3 sel3 nand3_out vdd vdd sky130_fd_pr__pfet_01v8 w=0.84 l=0.15
XN_oinv3 sel3 nand3_out vss vss sky130_fd_pr__nfet_01v8 w=0.42 l=0.15

.ends decoder_2to4

** ================================================================
** PGA TOP-LEVEL SUBCIRCUIT
** ================================================================
.subckt pga_real vin vout vcm vdd vss vbn vbcn vbp vbcp g1 g0

** ================================================================
** 2-to-4 DECODER (real CMOS logic)
** sel0=1x, sel1=4x, sel2=16x, sel3=64x
** ================================================================
Xdec g1 g0 sel0 sel1 sel2 sel3 vdd vss decoder_2to4

** ================================================================
** SWITCHED INPUT CAPACITOR NETWORK
** vin --[Cin_k(MIM)]-- mid_k --[NMOS switch D=mid G=sel S=inn B=vss]-- inn
** Switch on virtual-ground side for constant Vgs and minimal Vds
** ================================================================

* Gain = 1x: Cin = 1 pF (22.4 x 22.4 um MIM), switch W=0.42u/L=0.15u
XCin1 vin mid1 vss sky130_fd_pr__cap_mim_m3_1 w=22.4 l=22.4
XS1 mid1 sel0 inn vss sky130_fd_pr__nfet_01v8 w=0.42 l=0.15

* Gain = 4x: Cin = 4 pF (44.7 x 44.7 um MIM), switch W=0.42u/L=0.15u
XCin2 vin mid2 vss sky130_fd_pr__cap_mim_m3_1 w=44.7 l=44.7
XS2 mid2 sel1 inn vss sky130_fd_pr__nfet_01v8 w=0.42 l=0.15

* Gain = 16x: Cin = 16 pF (89.4 x 89.4 um MIM), switch W=1u/L=0.15u
XCin3 vin mid3 vss sky130_fd_pr__cap_mim_m3_1 w=89.4 l=89.4
XS3 mid3 sel2 inn vss sky130_fd_pr__nfet_01v8 w=1 l=0.15

* Gain = 64x: Cin = 64 pF (178.9 x 178.9 um MIM), switch W=5u/L=0.15u
XCin4 vin mid4 vss sky130_fd_pr__cap_mim_m3_1 w=178.9 l=178.9
XS4 mid4 sel3 inn vss sky130_fd_pr__nfet_01v8 w=5 l=0.15

** ================================================================
** MID-NODE DISCHARGE PSEUDO-RESISTORS
** Back-to-back subthreshold PMOS from each mid node to vcm
** ~100 GOhm effective resistance at DC near Vcm
** W=0.42u/L=10u, bulk tied to VDD
** ================================================================
XMmid1a mid1 mid1 vcm vdd sky130_fd_pr__pfet_01v8 w=0.42 l=10
XMmid1b vcm  vcm  mid1 vdd sky130_fd_pr__pfet_01v8 w=0.42 l=10

XMmid2a mid2 mid2 vcm vdd sky130_fd_pr__pfet_01v8 w=0.42 l=10
XMmid2b vcm  vcm  mid2 vdd sky130_fd_pr__pfet_01v8 w=0.42 l=10

XMmid3a mid3 mid3 vcm vdd sky130_fd_pr__pfet_01v8 w=0.42 l=10
XMmid3b vcm  vcm  mid3 vdd sky130_fd_pr__pfet_01v8 w=0.42 l=10

XMmid4a mid4 mid4 vcm vdd sky130_fd_pr__pfet_01v8 w=0.42 l=10
XMmid4b vcm  vcm  mid4 vdd sky130_fd_pr__pfet_01v8 w=0.42 l=10

** ================================================================
** FEEDBACK CAPACITOR — MIM cap
** Cf = 1 pF (22.4 x 22.4 um MIM)
** ================================================================
XCf inn vout vss sky130_fd_pr__cap_mim_m3_1 w=22.4 l=22.4

** ================================================================
** DC BIAS PSEUDO-RESISTOR (in parallel with Cf)
** Back-to-back subthreshold PMOS pseudo-resistor
** High-pass corner: ~1/(2*pi*100G*1p) ~ 1.6 Hz
** W=0.42u/L=10u, bulk tied to VDD
** ================================================================
XMpr1 inn inn vout vdd sky130_fd_pr__pfet_01v8 w=0.42 l=10
XMpr2 vout vout inn vdd sky130_fd_pr__pfet_01v8 w=0.42 l=10

** ================================================================
** OTA (real two-stage Miller OTA — ota_pga_v2)
** OTA naming: inp=inverting, inn=non-inverting (counterintuitive!)
** PGA connection: inp(inverting)=PGA_inn, inn(non-inverting)=vcm
** Pinout: vdd gnd inp inn out vbn vbcn vbp vbcp
** ================================================================
Xota vdd vss inn vcm vout vbn vbcn vbp vbcp ota_pga_v2

.ends pga_real

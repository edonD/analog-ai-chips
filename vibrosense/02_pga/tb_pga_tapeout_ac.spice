* TB: Tapeout-Ready PGA AC Analysis — All 4 Gain Settings
* Separate runs for each gain (avoids alter issues with CMOS decoder)
* Verifies gain accuracy within +/-0.5 dB at each setting

.option scale=1e-6
.include "../01_ota/ota_pga_v2/sky130_pdk_fixup.spice"
.lib "sky130_minimal.lib.spice" tt
.include "sky130_mim_cap_model.spice"
.include "../01_ota/ota_pga_v2/ota_pga_v2.spice"
.include "pga_real.spice"

** Supply
Vdd vdd 0 1.8
Vss vss 0 0
Vcm vcm 0 0.9

** Ideal bias voltages
Vbn  vbn  0 0.65
Vbcn vbcn 0 0.88
Vbp  vbp  0 0.73
Vbcp vbcp 0 0.475

** Input
Vin vin 0 DC 0.9 AC 1

** Gain select: 1x (g1=0, g0=0)
Vg1 g1 0 0
Vg0 g0 0 0

** PGA instance
Xpga vin vout vcm vdd vss vbn vbcn vbp vbcp g1 g0 pga_real

** Load
CL vout 0 10p

** Help convergence
.nodeset v(vout)=0.9 v(xpga.inn)=0.9
+ v(xpga.mid1)=0.9 v(xpga.mid2)=0.9 v(xpga.mid3)=0.9 v(xpga.mid4)=0.9

.control
* ============================================
* Gain = 1x (g1=0, g0=0) — already set
* ============================================
op
ac dec 100 1 10meg
meas ac gain_1x find vdb(vout) at=1000
meas ac gain_1x_25k find vdb(vout) at=25000
echo ""
echo "=== 1x: midband = $&gain_1x dB (target 0 dB) ==="

* ============================================
* Gain = 4x (g1=0, g0=1.8)
* ============================================
alter Vg0 = 1.8
op
ac dec 100 1 10meg
meas ac gain_4x find vdb(vout) at=1000
echo "=== 4x: midband = $&gain_4x dB (target 12.04 dB) ==="

* ============================================
* Gain = 16x (g1=1.8, g0=0)
* ============================================
alter Vg0 = 0
alter Vg1 = 1.8
op
ac dec 100 1 10meg
meas ac gain_16x find vdb(vout) at=1000
echo "=== 16x: midband = $&gain_16x dB (target 24.08 dB) ==="

* ============================================
* Gain = 64x (g1=1.8, g0=1.8)
* ============================================
alter Vg0 = 1.8
alter Vg1 = 1.8
op
ac dec 100 1 10meg
meas ac gain_64x find vdb(vout) at=1000
echo "=== 64x: midband = $&gain_64x dB (target 36.12 dB) ==="

echo ""
echo "============================================"
echo "  TAPEOUT AC VERIFICATION SUMMARY"
echo "============================================"
echo "  1x:  $&gain_1x dB   (target  0.00 dB)"
echo "  4x:  $&gain_4x dB   (target 12.04 dB)"
echo "  16x: $&gain_16x dB  (target 24.08 dB)"
echo "  64x: $&gain_64x dB  (target 36.12 dB)"
echo "============================================"
echo "  Spec: all errors within +/-0.5 dB"
echo "============================================"

quit
.endc

.end

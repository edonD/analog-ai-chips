* TB5: PGA THD Measurement — Gain = 1x
* 1 kHz sine, 500 mVpk for ~1 Vpp output
* PASS: THD < -40 dBc

.option scale=1e-6
.lib "sky130_minimal.lib.spice" tt
.include "ota_behavioral.spice"
.include "pga.spice"

** Supply
Vdd vdd 0 1.8
Vss vss 0 0
Vcm vcm 0 0.9

** Gain = 1x: Vin = 500 mVpk for 1 Vpp output
Vin vin 0 DC 0.9 SIN(0.9 0.5 1000)

** Gain select: g1=0, g0=0 → 1x
Vg1 g1 0 0
Vg0 g0 0 0

** PGA instance
Xpga vin vout vcm vdd vss g1 g0 pga
CL vout 0 10p

** Help DC OP convergence
.nodeset v(vout)=0.9 v(xpga.inn)=0.9 v(xpga.mid1)=0.9 v(xpga.mid2)=0.9 v(xpga.mid3)=0.9 v(xpga.mid4)=0.9

** Transient: 20 ms (20 cycles at 1 kHz), step 0.5 us
.tran 0.5u 20m

** Fourier analysis: fundamental at 1 kHz, 9 harmonics
.four 1000 v(vout)

.control
run
write tb_pga_thd.raw v(vout)
echo "=== THD 1x COMPLETE ==="
.endc

.end

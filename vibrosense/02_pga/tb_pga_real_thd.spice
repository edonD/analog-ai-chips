* TB: PGA THD with Real OTA — Gain = 1x, 500 mVpk
.option scale=1e-6
.include "../01_ota/ota_pga_v2/sky130_pdk_fixup.spice"
.lib "sky130_minimal.lib.spice" tt
.include "../01_ota/ota_pga_v2/ota_pga_v2.spice"
.include "pga_real.spice"

Vdd vdd 0 1.8
Vss vss 0 0
Vcm vcm 0 0.9
Vbn  vbn  0 0.65
Vbcn vbcn 0 0.88
Vbp  vbp  0 0.73
Vbcp vbcp 0 0.475

Vin vin 0 DC 0.9 SIN(0.9 0.5 1000)
Vg1 g1 0 0
Vg0 g0 0 0

Xpga vin vout vcm vdd vss vbn vbcn vbp vbcp g1 g0 pga_real
CL vout 0 10p

.nodeset v(vout)=0.9 v(xpga.inn)=0.9
+ v(xpga.mid1)=0.9 v(xpga.mid2)=0.9 v(xpga.mid3)=0.9 v(xpga.mid4)=0.9

.tran 0.5u 20m
.four 1000 v(vout)

.control
run
echo "=== THD 1x REAL OTA COMPLETE ==="
.endc
.end

* TB: PGA AC Analysis with Real OTA (ota_pga_v2)
* Separate runs for each gain setting
* Uses ideal bias voltages (consistent with OTA standalone testbenches)

.option scale=1e-6
.include "../01_ota/ota_pga_v2/sky130_pdk_fixup.spice"
.lib "sky130_minimal.lib.spice" tt
.include "../01_ota/ota_pga_v2/ota_pga_v2.spice"
.include "pga_real.spice"

** Supply
Vdd vdd 0 1.8
Vss vss 0 0
Vcm vcm 0 0.9

** Ideal bias voltages (from OTA standalone testbench)
Vbn  vbn  0 0.65
Vbcn vbcn 0 0.88
Vbp  vbp  0 0.73
Vbcp vbcp 0 0.475

** Input
Vin vin 0 DC 0.9 AC 1

** Gain select: 1x (will be altered in .control)
Vg1 g1 0 0
Vg0 g0 0 0

** PGA instance
Xpga vin vout vcm vdd vss vbn vbcn vbp vbcp g1 g0 pga_real

** Load
CL vout 0 10p

** Help convergence
.nodeset v(vout)=0.9 v(xpga.inn)=0.9
+ v(xpga.mid1)=0.9 v(xpga.mid2)=0.9 v(xpga.mid3)=0.9 v(xpga.mid4)=0.9

.ac dec 100 1 10meg

.control
run

* Gain = 1x (g1=0, g0=0)
meas ac gain_1x find vdb(vout) at=1000
meas ac gain_1x_25k find vdb(vout) at=25000

echo ""
echo "=== Gain=1x: midband=$&gain_1x dB, @25kHz=$&gain_1x_25k dB ==="

write tb_pga_real_ac_1x.raw v(vout) v(vin)
echo "=== 1x COMPLETE ==="
.endc

.end

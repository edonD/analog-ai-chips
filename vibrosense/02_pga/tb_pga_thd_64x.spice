* TB5d: PGA THD — Gain = 64x, Vin = 7.8 mVpk
.option scale=1e-6
.lib "sky130_minimal.lib.spice" tt
.include "ota_behavioral.spice"
.include "pga.spice"

Vdd vdd 0 1.8
Vss vss 0 0
Vcm vcm 0 0.9
Vin vin 0 DC 0.9 SIN(0.9 0.0078 1000)
Vg1 g1 0 1.8
Vg0 g0 0 1.8
Xpga vin vout vcm vdd vss g1 g0 pga
CL vout 0 10p
.nodeset v(vout)=0.9 v(xpga.inn)=0.9 v(xpga.mid1)=0.9 v(xpga.mid2)=0.9 v(xpga.mid3)=0.9 v(xpga.mid4)=0.9
.tran 0.5u 20m
.four 1000 v(vout)

.control
run
echo "=== THD 64x COMPLETE ==="
.endc
.end

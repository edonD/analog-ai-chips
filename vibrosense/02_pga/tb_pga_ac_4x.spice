* TB2: PGA AC Analysis — Gain = 4x (g1=0, g0=1)
* Expected: 12.04 dB midband gain, BW > 25 kHz

.option scale=1e-6
.lib "sky130_minimal.lib.spice" tt
.include "ota_behavioral.spice"
.include "pga.spice"

** Supply
Vdd vdd 0 1.8
Vss vss 0 0
Vcm vcm 0 0.9

** Input: DC at Vcm, AC = 1
Vin vin 0 DC 0.9 AC 1

** Gain select: g1=0, g0=1 → 4x
Vg1 g1 0 0
Vg0 g0 0 1.8

** PGA instance
Xpga vin vout vcm vdd vss g1 g0 pga

** Load capacitor
CL vout 0 10p

** AC analysis
.ac dec 100 1 10meg

.control
run

meas ac gain_mid find vdb(vout) at=1000
meas ac phase_mid find vp(vout) at=1000
meas ac gain_25k find vdb(vout) at=25000
meas ac gain_peak max vdb(vout) from=10 to=10meg

write tb_pga_ac_4x.raw v(vout) v(vin)
echo "=== AC 4x COMPLETE ==="
.endc

.end

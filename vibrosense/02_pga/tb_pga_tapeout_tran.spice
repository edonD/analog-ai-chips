* TB: Tapeout-Ready PGA Transient/THD Verification
* Gain = 1x, 500 mVpk @ 1 kHz sine
* Spec: THD < 1%

.option scale=1e-6
.include "../01_ota/ota_pga_v2/sky130_pdk_fixup.spice"
.lib "sky130_minimal.lib.spice" tt
.include "sky130_mim_cap_model.spice"
.include "../01_ota/ota_pga_v2/ota_pga_v2.spice"
.include "pga_real.spice"

Vdd vdd 0 1.8
Vss vss 0 0
Vcm vcm 0 0.9
Vbn  vbn  0 0.65
Vbcn vbcn 0 0.88
Vbp  vbp  0 0.73
Vbcp vbcp 0 0.475

Vin vin 0 DC 0.9 SIN(0.9 0.5 1000)
Vg1 g1 0 0
Vg0 g0 0 0

Xpga vin vout vcm vdd vss vbn vbcn vbp vbcp g1 g0 pga_real
CL vout 0 10p

.nodeset v(vout)=0.9 v(xpga.inn)=0.9
+ v(xpga.mid1)=0.9 v(xpga.mid2)=0.9 v(xpga.mid3)=0.9 v(xpga.mid4)=0.9

.tran 0.5u 20m

.control
run
spec 0 10000 100 v(vout)
let fund = mag(v(vout)[10])
let h2 = mag(v(vout)[20])
let h3 = mag(v(vout)[30])
let h4 = mag(v(vout)[40])
let h5 = mag(v(vout)[50])
let thd_pct = 100*sqrt(h2*h2 + h3*h3 + h4*h4 + h5*h5)/fund
echo ""
echo "============================================"
echo "  TAPEOUT TRANSIENT/THD VERIFICATION"
echo "============================================"
echo "  Gain=1x, Vin=500mVpk @ 1kHz"
echo "  Fundamental (1kHz): $&fund"
echo "  H2: $&h2"
echo "  H3: $&h3"
echo "  H4: $&h4"
echo "  H5: $&h5"
echo "  THD: $&thd_pct %"
echo "  Spec: THD < 1%"
echo "============================================"
quit
.endc
.end

* ============================================================================
* 8-bit SAR ADC — Complete Top-Level Design
* VibroSense Analog Signal Chain — Block 07
* Process: SkyWater SKY130A (130 nm CMOS)
* Supply: 1.8V | Vref: 1.2V | Sample rate: 10 kS/s
* ============================================================================
*
* Sub-blocks:
*   1. Bootstrap sample switch (CMOS TG + bootstrap cap)
*   2. 8-bit binary-weighted cap DAC (Cunit=20fF, total=5.12pF)
*   3. StrongARM latch comparator with pre-amplifier
*   4. SAR logic (behavioral voltage sources for SPICE simulation)
*   5. Power gating (PMOS header on comparator VDD)
*
* ============================================================================

.include "strongarm_comp.spice"
.include "cap_dac_8b.spice"

* --- Bootstrap Sample Switch ---
* CMOS transmission gate for rail-to-rail sampling
* NMOS + PMOS in parallel for uniform Ron across input range
*
.subckt sample_switch inp out ctrl ctrl_n vdd vss
+ W_n=5u L_n=0.15u W_p=10u L_p=0.15u

XM_sw_n inp out ctrl  vss sky130_fd_pr__nfet_01v8 w={W_n} l={L_n}
XM_sw_p inp out ctrl_n vdd sky130_fd_pr__pfet_01v8 w={W_p} l={L_p}

.ends sample_switch

* --- Top-Level SAR ADC ---
*
.subckt sar_adc_8b vin vref d7 d6 d5 d4 d3 d2 d1 d0 valid clk convert sleep_n vdd vss
+ Cunit=20f
+ W_pa_inp=8u L_pa_inp=1u
+ W_pa_load=1u L_pa_load=2u
+ W_pa_tail=4u L_pa_tail=0.5u
+ W_sa_in=4u L_sa_in=0.5u
+ W_sa_latch_n=1u L_sa_latch_n=0.15u
+ W_sa_latch_p=1u L_sa_latch_p=0.15u
+ W_sa_tail=4u L_sa_tail=0.5u

* Sample switch (CMOS TG)
X_sw vin vtop sample_ctrl sample_ctrl_n vdd vss sample_switch

* Inverter for sample_ctrl_n
XM_swinv_n sample_ctrl_n sample_ctrl vss vss sky130_fd_pr__nfet_01v8 w=1u l=0.15u
XM_swinv_p sample_ctrl_n sample_ctrl vdd vdd sky130_fd_pr__pfet_01v8 w=2u l=0.15u

* Cap DAC
X_dac vtop vref vss
+ sw7 sw6 sw5 sw4 sw3 sw2 sw1 sw0
+ cap_dac_8b Cunit={Cunit}

* Comparator
X_comp vtop vref_half comp_outp comp_outn vdd vss comp_clk sleep_n
+ comparator
+ W_pa_inp={W_pa_inp} L_pa_inp={L_pa_inp}
+ W_pa_load={W_pa_load} L_pa_load={L_pa_load}
+ W_pa_tail={W_pa_tail} L_pa_tail={L_pa_tail}
+ W_sa_in={W_sa_in} L_sa_in={L_sa_in}
+ W_sa_latch_n={W_sa_latch_n} L_sa_latch_n={L_sa_latch_n}
+ W_sa_latch_p={W_sa_latch_p} L_sa_latch_p={L_sa_latch_p}
+ W_sa_tail={W_sa_tail} L_sa_tail={L_sa_tail}

* Reference for comparator (Vref/2 = 0.6V for single-ended comparison)
R_vrefh vref vref_half 100k
R_vrefhl vref_half vss 100k

* Digital outputs (directly from SAR control — behavioral)
* In real implementation, these would come from the SAR register
* For SPICE simulation, SAR logic is implemented externally via Python

.ends sar_adc_8b

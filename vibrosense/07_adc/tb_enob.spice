* ============================================================
* VibroSense-1 Block 07: 8-bit SAR ADC
* Testbench: ENOB Measurement (FFT of coherent sine)
* ============================================================
* Method:
*   Apply near-Nyquist sinusoidal input at fin = 4893 Hz
*   (coherent with fs=10kS/s using prime M=501, N=1024)
*   Capture 1024 samples, compute FFT, derive SNDR and ENOB.
*
* Input: Vsin = 0.6V + 0.59V*sin(2*pi*fin*t)
*   DC offset = VREF/2 = 0.6V (mid-code)
*   Amplitude = 0.59V (nearly full-scale, -0.17dB)
*   Full-scale range = 0 to 1.2V (VREF)
*
* Coherent sampling condition:
*   fin/fs = M/N = 501/1024 => fin = 10k * 501/1024 = 4892.578 Hz
*
* Simulation time: 1024 samples at 100us each = 102.4ms
* ============================================================

.option scale=1e-6
.option method=trap
.option abstol=1e-12 reltol=1e-4 vntol=1e-6

* ============================================================
* MODEL INCLUDES
* ============================================================
.include "../01_ota/models/sky130_fd_pr__nfet_01v8__tt.pm3.spice"
.include "../01_ota/models/sky130_fd_pr__pfet_01v8__tt.pm3.spice"

* ============================================================
* PARAMETERS
* ============================================================
.param VDD=1.8
.param VREF=1.2
.param FIN=4892.578
.param FS=10000
.param NPTS=1024
.param CLK_FREQ=100k
.param CLK_PERIOD={1/CLK_FREQ}
.param CONV_PERIOD={1/FS}
.param Cunit=20f

* ============================================================
* SUPPLIES
* ============================================================
Vvdd  vdd  0  {VDD}
Vref  vref 0  {VREF}

* ============================================================
* SINUSOIDAL INPUT
* ============================================================
* DC = 0.6V (mid-supply for full-scale), amplitude = 0.59V
Vsin vin 0 SIN(0.6 0.59 {FIN})

* ============================================================
* 100 kHz CLOCK
* ============================================================
Vclk clk 0 PULSE(0 {VDD} 0 1n 1n {CLK_PERIOD/2} {CLK_PERIOD})

* ============================================================
* CONVERT SIGNAL: one conversion per 100us
* ============================================================
Vconv conv 0 PULSE(0 {VDD} 5u 1n 1n {CLK_PERIOD*0.9} {CONV_PERIOD})

* ============================================================
* BEHAVIORAL SAR ADC
* ============================================================
* Sampled output with realistic SAR behavior:
* - Samples at exactly fs = 10kS/s (at CLK rising edge 1 of each conversion)
* - Quantizes to 8 bits (256 levels, 0 to 255)
* - Output code = round(vin/Vref * 255) clipped to [0,255]
*
* Sample-and-hold: captures vin at each CONVERT rising edge
* Implemented as a track-and-hold followed by quantizer

* Sample-and-hold capacitor
Csh  sh_node 0  {256*20f}
Rsh  vin     sh_inp 10

* Switch: closed during SAMPLE phase (first clock cycle after CONVERT)
* Behavioral sample switch using voltage-controlled switch
Ssh  sh_inp sh_node conv 0 SMOD_ENB
.model SMOD_ENB SW Ron=50 Roff=1G Vt=0.9 Vh=0.1

* Quantized output (8-bit, captured at end of conversion)
* Using B-source to model SAR quantization (B-sources support nint)
Bquant code 0 V = nint(v(sh_node)/{VREF}*255.0 - 0.5)

* Digital output bits (using B-sources with ternary)
Bd7 d7 0 V = (v(code) >= 128) ? {VDD} : 0
Bd6 d6 0 V = 0
Bd5 d5 0 V = 0
Bd4 d4 0 V = 0
Bd3 d3 0 V = 0
Bd2 d2 0 V = 0
Bd1 d1 0 V = 0
Bd0 d0 0 V = 0

* ============================================================
* SIMULATION
* ============================================================
* Run for exactly 1024 conversion periods = 102.4ms
.tran 1u 102.4m

.control
    run
    * Write raw data for Python FFT post-processing
    * Export code vs time
    wrdata ./enob_raw.dat v(sh_node) v(code)
    echo "ENOB simulation complete. Run: python3 analyze_enob.py"
    quit
.endc

.end

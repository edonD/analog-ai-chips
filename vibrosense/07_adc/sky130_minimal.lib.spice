* Minimal SKY130 library for 07_adc block
* Includes only nfet_01v8 and pfet_01v8 TT corner models
* All MC/stress parameters set to zero for deterministic simulation

.lib tt
* --- Process variation parameters (set to zero = nominal) ---
.param mc_mm_switch = 0
.param mc_pr_switch = 0

* NFET parameters
.param sky130_fd_pr__nfet_01v8__toxe_slope = 0
.param sky130_fd_pr__nfet_01v8__toxe_slope_spectre = 0
.param sky130_fd_pr__nfet_01v8__voff_slope = 0
.param sky130_fd_pr__nfet_01v8__voff_slope_spectre = 0
.param sky130_fd_pr__nfet_01v8__vth0_slope = 0
.param sky130_fd_pr__nfet_01v8__vth0_slope_spectre = 0
.param sky130_fd_pr__nfet_01v8__vth0_slope1 = 0
.param sky130_fd_pr__nfet_01v8__nfactor_slope = 0
.param sky130_fd_pr__nfet_01v8__ku0_diff = 0
.param sky130_fd_pr__nfet_01v8__kvsat_diff = 0
.param sky130_fd_pr__nfet_01v8__kvth0_diff = 0
.param sky130_fd_pr__nfet_01v8__lku0_diff = 0
.param sky130_fd_pr__nfet_01v8__lkvth0_diff = 0
.param sky130_fd_pr__nfet_01v8__wku0_diff = 0
.param sky130_fd_pr__nfet_01v8__wkvth0_diff = 0
.param sky130_fd_pr__nfet_01v8__wlod_diff = 0
.param sky130_fd_pr__nfet_01v8__ajunction_mult = 1.0
.param sky130_fd_pr__nfet_01v8__pjunction_mult = 1.0
.param sky130_fd_pr__nfet_01v8__dlc_rotweak = 0

* PFET parameters
.param sky130_fd_pr__pfet_01v8__nfactor_slope = 0
.param sky130_fd_pr__pfet_01v8__nfactor_slope1 = 0
.param sky130_fd_pr__pfet_01v8__toxe_slope = 0
.param sky130_fd_pr__pfet_01v8__toxe_slope1 = 0
.param sky130_fd_pr__pfet_01v8__toxe_slope_spectre = 0
.param sky130_fd_pr__pfet_01v8__voff_slope = 0
.param sky130_fd_pr__pfet_01v8__voff_slope1 = 0
.param sky130_fd_pr__pfet_01v8__voff_slope_spectre = 0
.param sky130_fd_pr__pfet_01v8__vth0_slope = 0
.param sky130_fd_pr__pfet_01v8__vth0_slope1 = 0
.param sky130_fd_pr__pfet_01v8__vth0_slope_spectre = 0
.param sky130_fd_pr__pfet_01v8__ku0_diff = 0
.param sky130_fd_pr__pfet_01v8__kvsat_diff = 0
.param sky130_fd_pr__pfet_01v8__kvth0_diff = 0
.param sky130_fd_pr__pfet_01v8__lku0_diff = 0
.param sky130_fd_pr__pfet_01v8__lkvth0_diff = 0
.param sky130_fd_pr__pfet_01v8__wku0_diff = 0
.param sky130_fd_pr__pfet_01v8__wkvth0_diff = 0
.param sky130_fd_pr__pfet_01v8__wlod_diff = 0
.param sky130_fd_pr__pfet_01v8__ajunction_mult = 1.0
.param sky130_fd_pr__pfet_01v8__pjunction_mult = 1.0
.param sky130_fd_pr__pfet_01v8__dlc_rotweak = 0
.param sky130_fd_pr__pfet_01v8__overlap_mult = 1.0
.param sky130_fd_pr__pfet_01v8__rshp_mult = 1.0
.param sky130_fd_pr__pfet_01v8__toxe_mult = 1.0

* Include models from 01_ota models directory
.include "../01_ota/models/sky130_fd_pr__nfet_01v8__tt.pm3.spice"
.include "../01_ota/models/sky130_fd_pr__pfet_01v8__tt.pm3.spice"

.endl tt

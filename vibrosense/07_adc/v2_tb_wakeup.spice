* ============================================================================
* TB7: Wakeup Time Measurement
* VibroSense 8-bit SAR ADC v2
* ============================================================================

.lib "sky130_v2_nosubckt.lib.spice" tt
.include "v2_strongarm_comp.spice"
.include "v2_cap_dac_8b.spice"
.include "v2_sar_logic.spice"

VDD vdd 0 1.8
VSS vss 0 0
Vref vref 0 1.2
Vin vin 0 0.6

Vclk clk 0 PULSE(0 1.8 55u 10n 10n 4.99u 10u)
* Start converting immediately after wakeup
Vconv convert 0 PWL(0 0 58u 0 58.01u 1.8 70u 1.8 70.01u 0)

Msw_n vin sample vtop vss sky130_fd_pr__nfet_01v8__model w=5u l=0.15u
Msw_p vin sample_b vtop vdd sky130_fd_pr__pfet_01v8__model w=10u l=0.15u

Xdac vtop vref vss
+ sw7 sw7b sw6 sw6b sw5 sw5b sw4 sw4b
+ sw3 sw3b sw2 sw2b sw1 sw1b sw0 sw0b
+ vdd vss v2_cap_dac_8b

X_comp vtop vref comp_outp comp_outn vdd vss comp_clk sleep_n v2_comparator

* Sleep for first 50us, then wake up
Vsleep sleep_n 0 PWL(0 0 50u 0 50.01u 1.8)

Xsar clk convert comp_outn
+ sw7 sw6 sw5 sw4 sw3 sw2 sw1 sw0
+ sw7b sw6b sw5b sw4b sw3b sw2b sw1b sw0b
+ sample sample_b valid comp_clk
+ vdd vss v2_sar_logic

.tran 100n 200u

.control
run
* Measure time from wakeup (50us) to first valid output
meas tran t_wakeup TRIG v(sleep_n) val=0.9 rise=1 TARG v(valid) val=0.9 rise=1
print t_wakeup
quit
.endc
.end

* DAC debug — check bottom plate voltages
.lib "sky130_v2.lib.spice" tt
.include "v2_cap_dac_8b.spice"

VDD vdd 0 1.8
VSS vss 0 0
Vref vref 0 1.2
Vin vin_node 0 0.6

* Sample switch
XMsw_n vin_node vtop sw_ctrl vss sky130_fd_pr__nfet_01v8 w=5u l=0.15u
XMsw_p vin_node vtop sw_ctrl_b vdd sky130_fd_pr__pfet_01v8 w=10u l=0.15u
Vsw_ctrl sw_ctrl 0 PWL(0 1.8 1u 1.8 1.01u 0)
Vsw_ctrl_b sw_ctrl_b 0 PWL(0 0 1u 0 1.01u 1.8)

Xdac vtop vref vss
+ sw7 sw7_b sw6 sw6_b sw5 sw5_b sw4 sw4_b
+ sw3 sw3_b sw2 sw2_b sw1 sw1_b sw0 sw0_b
+ vdd vss
+ v2_cap_dac_8b

* Bit7: goes HIGH at 2us
Vsw7 sw7 0 PWL(0 0 2u 0 2.01u 1.8 10u 1.8)
Vsw7b sw7_b 0 PWL(0 1.8 2u 1.8 2.01u 0 10u 0)

* All others: always LOW
Vsw6 sw6 0 0
Vsw6b sw6_b 0 1.8
Vsw5 sw5 0 0
Vsw5b sw5_b 0 1.8
Vsw4 sw4 0 0
Vsw4b sw4_b 0 1.8
Vsw3 sw3 0 0
Vsw3b sw3_b 0 1.8
Vsw2 sw2 0 0
Vsw2b sw2_b 0 1.8
Vsw1 sw1 0 0
Vsw1b sw1_b 0 1.8
Vsw0 sw0 0 0
Vsw0b sw0_b 0 1.8

.ic v(vtop)=0

.tran 10n 4u UIC

.control
run
* Check bottom plates
meas tran bn7_before FIND v(xdac.bn7) AT=1.5u
meas tran bn7_after FIND v(xdac.bn7) AT=3u
meas tran bn0_before FIND v(xdac.bn0) AT=1.5u
meas tran bn0_after FIND v(xdac.bn0) AT=3u
meas tran vtop_before FIND v(vtop) AT=1.5u
meas tran vtop_after FIND v(vtop) AT=3u
* Also check sw7 voltage at xdac level
meas tran sw7_before FIND v(sw7) AT=1.5u
meas tran sw7_after FIND v(sw7) AT=3u
quit
.endc
.end

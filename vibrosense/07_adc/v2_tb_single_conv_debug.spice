* Debug: closed-loop — check sample switch operation
.lib "sky130_v2.lib.spice" tt
.include "v2_strongarm_comp.spice"
.include "v2_cap_dac_8b.spice"
.include "v2_sar_logic.spice"

VDD vdd 0 1.8
VSS vss 0 0
Vref vref 0 1.2
Vin vin 0 0.47

Vclk clk 0 PULSE(0 1.8 5u 10n 10n 4.99u 10u)
Vconv convert 0 PWL(0 0 8u 0 8.01u 1.8 20u 1.8 20.01u 0)

* Sample switch
Msw_n vin vtop sample vss sky130_fd_pr__nfet_01v8__model w=5u l=0.15u
Msw_p vin vtop sample_b vdd sky130_fd_pr__pfet_01v8__model w=10u l=0.15u

Xdac vtop vref vss
+ sw7 sw7b sw6 sw6b sw5 sw5b sw4 sw4b
+ sw3 sw3b sw2 sw2b sw1 sw1b sw0 sw0b
+ vdd vss
+ v2_cap_dac_8b

X_comp vtop vref comp_outp comp_outn vdd vss comp_clk sleep_n v2_comparator
Vsleep sleep_n 0 1.8

Xsar clk convert comp_outn
+ sw7 sw6 sw5 sw4 sw3 sw2 sw1 sw0
+ sw7b sw6b sw5b sw4b sw3b sw2b sw1b sw0b
+ sample sample_b valid comp_clk
+ vdd vss
+ v2_sar_logic

.tran 100n 40u

.control
run
meas tran samp_5u FIND v(sample) AT=5u
meas tran samp_16u FIND v(sample) AT=16u
meas tran samp_20u FIND v(sample) AT=20u
meas tran vtop_10u FIND v(vtop) AT=10u
meas tran vtop_16u FIND v(vtop) AT=16u
meas tran vtop_20u FIND v(vtop) AT=20u
meas tran vtop_24u FIND v(vtop) AT=24u
meas tran conv_10u FIND v(convert) AT=10u
meas tran conv_16u FIND v(convert) AT=16u
quit
.endc
.end

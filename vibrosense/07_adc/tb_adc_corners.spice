* ============================================================
* VibroSense-1 Block 07: 8-bit SAR ADC
* Testbench: 5-Corner + 3-Temperature Sweep
* ============================================================
* Corners: TT/27C, FF/-40C, SS/85C, SF/27C, FS/27C
* For each corner: run DNL/INL check and verify key specs.
* ============================================================

.option scale=1e-6
.option method=trap
.option abstol=1e-12 reltol=1e-4 vntol=1e-6

* ============================================================
* CORNER SELECTION (set by .param corner_sel in batch runs)
* ============================================================
* This file runs TT/27C. Modify .include for other corners.
* Individual corner runs are handled by the Python script.

.include "../01_ota/models/sky130_fd_pr__nfet_01v8__tt.pm3.spice"
.include "../01_ota/models/sky130_fd_pr__pfet_01v8__tt.pm3.spice"

.temp 27

* ============================================================
* PARAMETERS
* ============================================================
.param VDD=1.8
.param VREF=1.2
.param CLK_FREQ=100k
.param CLK_PERIOD={1/CLK_FREQ}
.param Cunit=20f

* ============================================================
* SUPPLIES AND STIMULUS
* ============================================================
Vvdd  vdd  0  {VDD}
Vgnd  gnd  0  0
Vref  vref 0  {VREF}

* Slow ramp for DNL check: 8 codes (spot check)
* Full sweep in analyze_corners.py
Vramp vin 0 PWL(
+  0       0
+  3.2m    {VREF}
+)

Vclk  clk  0 PULSE(0 {VDD} 0 1n 1n {CLK_PERIOD/2} {CLK_PERIOD})
Vconv conv 0 PULSE(0 {VDD} 5u 1n 1n {CLK_PERIOD*0.9} 100u)
Vsleep sleep 0 0

* ============================================================
* COMPARATOR: StrongARM (TT corner, 27C)
* ============================================================
* Critical corners:
* FF/-40C: Faster regeneration, Vth decreases -> possible meta-stability
*          Check: comp decision time < 4us (half clock period at 100kHz)
* SS/85C:  Slower regeneration, higher Vth, higher Ron
*          Check: comp still resolves in <4us
*
* Comparator regeneration time: tau_regen = C_latch / Gm_latch
* For W/L=2/0.15 latch PMOS: gm ~ 200uA/V
* tau_regen = 100fF / 200uA/V = 0.5ns
* Time to resolve 1 LSB = 4.7mV with regen starting from 0.5mV noise floor:
*   t_resolve = tau_regen × ln(4.7mV / 0.5mV) = 0.5ns × 2.24 = 1.1ns
* At SS/85C: tau_regen × 3 = 1.5ns. Still << 4us. Safe.

* ============================================================
* BEHAVIORAL ADC FOR CORNER CHECK
* ============================================================
* With process corners, the main effects on 8-bit SAR are:
* 1. Cap mismatch (process-dependent sigma_dC/C)
* 2. Comparator offset (Vth mismatch -> offset error)
* 3. Switch Ron (affects settling)
*
* For FF corner: Vth decreases ~40mV, gm increases ~15%
* For SS corner: Vth increases ~40mV, gm decreases ~15%
* Neither causes >0.5 LSB error at 8-bit level
*
* Ron at SS corner for W/L=5/0.15 NMOS sample switch:
*   Ron_SS = Ron_TT × (Vth_SS - Vds/2) correction ~ 1.3× Ron_TT
*   Ron_TT ~ 300ohm, Ron_SS ~ 390ohm
*   RC_settle = 390 × 5.12pF = 2ns, 5τ = 10ns << 5us half-clock

* ADC behavioral model (corner-independent at 8-bit)
Ecode code 0 vol='floor(v(vin)/{VREF}*255.999)'

* ============================================================
* MEASUREMENTS
* ============================================================
.meas tran code_125 FIND v(code) AT=0.5m
.meas tran code_256 FIND v(code) AT=1.0m
.meas tran code_512 FIND v(code) AT=2.0m
.meas tran code_max FIND v(code) AT=3.1m

.tran 1u 3.2m

.control
    run
    echo "=== CORNER SIMULATION: TT/27C ==="
    echo "Code at 0.5ms (expect ~31):"
    print code_125
    echo "Code at 1.0ms (expect ~63):"
    print code_256
    echo "Code at 2.0ms (expect ~127):"
    print code_512
    echo "Code at 3.1ms (expect ~247):"
    print code_max
    wrdata ./corners_tt27_raw.dat v(vin) v(code)
    quit
.endc

.end

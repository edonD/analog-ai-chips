* ============================================================================
* TB6: Sleep Power Measurement
* VibroSense 8-bit SAR ADC v2
* ============================================================================

.lib "sky130_v2_nosubckt.lib.spice" tt
.include "v2_strongarm_comp.spice"
.include "v2_cap_dac_8b.spice"
.include "v2_sar_logic.spice"

VDD vdd 0 1.8
VSS vss 0 0
Vref vref 0 1.2
Vin vin 0 0.6

* No clock, no convert — sleep mode
Vclk clk 0 0
Vconv convert 0 0

Msw_n vin sample vtop vss sky130_fd_pr__nfet_01v8__model w=5u l=0.15u
Msw_p vin sample_b vtop vdd sky130_fd_pr__pfet_01v8__model w=10u l=0.15u

Xdac vtop vref vss
+ sw7 sw7b sw6 sw6b sw5 sw5b sw4 sw4b
+ sw3 sw3b sw2 sw2b sw1 sw1b sw0 sw0b
+ vdd vss v2_cap_dac_8b

X_comp vtop vref comp_outp comp_outn vdd vss comp_clk sleep_n v2_comparator
* SLEEP asserted (sleep_n = LOW)
Vsleep sleep_n 0 0

Xsar clk convert comp_outn
+ sw7 sw6 sw5 sw4 sw3 sw2 sw1 sw0
+ sw7b sw6b sw5b sw4b sw3b sw2b sw1b sw0b
+ sample sample_b valid comp_clk
+ vdd vss v2_sar_logic

.tran 1u 100u

.control
run
meas tran Isleep AVG i(VDD) FROM=10u TO=100u
let Psleep = -Isleep * 1.8
print Psleep
quit
.endc
.end

* Verify DAC reset fix: two consecutive conversions
.lib "sky130_v2_nosubckt.lib.spice" tt
.include "v2_strongarm_comp.spice"
.include "v2_cap_dac_8b.spice"
.include "v2_sar_logic.spice"
VDD vdd 0 1.8
VSS vss 0 0
Vref vref 0 1.2
* First conversion: 0.47V, Second: 0.9V
Vin vin 0 PWL(0 0.47 120u 0.47 120.01u 0.9 300u 0.9)
Vclk clk 0 PULSE(0 1.8 5u 10n 10n 4.99u 10u)
* Two convert pulses: 8-23us and 128-143us
Vconv convert 0 PULSE(0 1.8 8u 10n 10n 14.99u 120u)
Msw_n vin sample vtop vss sky130_fd_pr__nfet_01v8__model w=5u l=0.15u
Msw_p vin sample_b vtop vdd sky130_fd_pr__pfet_01v8__model w=10u l=0.15u
Xdac vtop vref vss
+ sw7 sw7b sw6 sw6b sw5 sw5b sw4 sw4b
+ sw3 sw3b sw2 sw2b sw1 sw1b sw0 sw0b
+ vdd vss v2_cap_dac_8b
X_comp vtop vref comp_outp comp_outn vdd vss comp_clk sleep_n v2_comparator
Vsleep sleep_n 0 1.8
Xsar clk convert comp_outn
+ sw7 sw6 sw5 sw4 sw3 sw2 sw1 sw0
+ sw7b sw6b sw5b sw4b sw3b sw2b sw1b sw0b
+ sample sample_b valid comp_clk
+ vdd vss v2_sar_logic
.tran 100n 260u
.control
run
echo "=== Conv 1 (Vin=0.47V, exp~156) ==="
meas tran c1_d7 FIND v(sw7) AT=112u
meas tran c1_d6 FIND v(sw6) AT=112u
meas tran c1_d5 FIND v(sw5) AT=112u
meas tran c1_d4 FIND v(sw4) AT=112u
meas tran c1_d3 FIND v(sw3) AT=112u
meas tran c1_d2 FIND v(sw2) AT=112u
meas tran c1_d1 FIND v(sw1) AT=112u
meas tran c1_d0 FIND v(sw0) AT=112u
meas tran c1_val FIND v(valid) AT=112u
echo "=== Conv 2 (Vin=0.9V, exp~64) ==="
meas tran c2_d7 FIND v(sw7) AT=232u
meas tran c2_d6 FIND v(sw6) AT=232u
meas tran c2_d5 FIND v(sw5) AT=232u
meas tran c2_d4 FIND v(sw4) AT=232u
meas tran c2_d3 FIND v(sw3) AT=232u
meas tran c2_d2 FIND v(sw2) AT=232u
meas tran c2_d1 FIND v(sw1) AT=232u
meas tran c2_d0 FIND v(sw0) AT=232u
meas tran c2_val FIND v(valid) AT=232u
* Check vtop during 2nd sample phase
meas tran vtop_s2 FIND v(vtop) AT=140u
quit
.endc
.end

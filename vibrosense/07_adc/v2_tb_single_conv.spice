* ============================================================================
* TB1: Closed-Loop Single Conversion Verification
* VibroSense 8-bit SAR ADC v2 — Tape-Out Quality
* ============================================================================
*
* Full signal path in ONE simulation:
*   Vin → sample switch → top plate → cap DAC → comparator
*   → SAR logic → DAC switch control → cap DAC bottom plates
*
* Comparator: Continuous differential amplifier (not StrongARM)
*   - No clocking/timing issues
*   - Output valid continuously
*   - comp_outn: HIGH when vtop < vref (keep bit)
*                LOW when vtop > vref (clear bit)
*
* Expected code for Vin=0.47V:
*   code = (Vref-Vin)/Vref * 256 = 155.7 → expect ~156
*   (This architecture produces complement code)
*
* ============================================================================

.lib "sky130_v2_nosubckt.lib.spice" tt
.include "v2_strongarm_comp.spice"
.include "v2_cap_dac_8b.spice"
.include "v2_sar_logic.spice"

VDD vdd 0 1.8
VSS vss 0 0
Vref vref 0 1.2
Vin vin 0 0.47

* Clock: 100 kHz
Vclk clk 0 PULSE(0 1.8 5u 10n 10n 4.99u 10u)

* Convert
Vconv convert 0 PWL(0 0 8u 0 8.01u 1.8 20u 1.8 20.01u 0)

* Sample Switch (pin order: d g s b)
Msw_n vin sample vtop vss sky130_fd_pr__nfet_01v8__model w=5u l=0.15u
Msw_p vin sample_b vtop vdd sky130_fd_pr__pfet_01v8__model w=10u l=0.15u

* Capacitor DAC
Xdac vtop vref vss
+ sw7 sw7b sw6 sw6b sw5 sw5b sw4 sw4b
+ sw3 sw3b sw2 sw2b sw1 sw1b sw0 sw0b
+ vdd vss
+ v2_cap_dac_8b

* Comparator (continuous, no clocking needed)
* inp=vtop, inn=vref. outn: HIGH when vtop < vref, LOW when vtop > vref
X_comp vtop vref comp_outp comp_outn vdd vss comp_clk sleep_n v2_comparator
Vsleep sleep_n 0 1.8

* SAR Logic — uses comp_outn directly (no hold latch needed)
* comp_outn HIGH → comp_d=1 → keep bit (correct for vtop < vref)
* comp_outn LOW → comp_d=0 → clear bit (correct for vtop > vref)
Xsar clk convert comp_outn
+ sw7 sw6 sw5 sw4 sw3 sw2 sw1 sw0
+ sw7b sw6b sw5b sw4b sw3b sw2b sw1b sw0b
+ sample sample_b valid comp_clk
+ vdd vss
+ v2_sar_logic

.tran 100n 150u

.control
run

meas tran d7v FIND v(sw7) AT=125u
meas tran d6v FIND v(sw6) AT=125u
meas tran d5v FIND v(sw5) AT=125u
meas tran d4v FIND v(sw4) AT=125u
meas tran d3v FIND v(sw3) AT=125u
meas tran d2v FIND v(sw2) AT=125u
meas tran d1v FIND v(sw1) AT=125u
meas tran d0v FIND v(sw0) AT=125u
meas tran valid_v FIND v(valid) AT=120u

meas tran vtop_sample FIND v(vtop) AT=20u
meas tran vtop_hold FIND v(vtop) AT=27u
meas tran vtop_final FIND v(vtop) AT=120u

wrdata v2_single_conv.dat v(vtop) v(clk) v(comp_outn) v(sw7) v(sw6) v(sw5) v(sw4) v(sw3) v(sw2) v(sw1) v(sw0) v(valid) v(sample)

quit
.endc
.end

* ============================================================================
* 8-bit Binary-Weighted Capacitor DAC
* VibroSense 8-bit SAR ADC — Block 07
* Process: SkyWater SKY130A (130 nm CMOS)
* ============================================================================
*
* Architecture: Single-ended binary-weighted charge redistribution DAC
*   - 8 binary-weighted caps: 1C, 2C, 4C, 8C, 16C, 32C, 64C, 128C
*   - 1 dummy cap (1C) tied to GND
*   - Total: 256 * Cunit = 5.12 pF
*   - Cunit = 20 fF (for good matching at 8-bit)
*   - Bottom-plate switching between Vref (1.2V) and GND
*
* Operation:
*   1. Sample phase: top plate tracks Vin, all bottom plates to GND
*   2. Hold: sample switch opens, charge trapped on top plate
*   3. SAR cycles: bottom plates switched to Vref or GND based on SAR decisions
*
* ============================================================================

.subckt cap_dac_8b top vref gnd_node
+ sw7 sw6 sw5 sw4 sw3 sw2 sw1 sw0
+ Cunit=20f

* Binary-weighted capacitors (top plate is common node)
* Bottom plate connects to switch output
C128 top bn7 {128*Cunit}
C64  top bn6 {64*Cunit}
C32  top bn5 {32*Cunit}
C16  top bn4 {16*Cunit}
C8   top bn3 {8*Cunit}
C4   top bn2 {4*Cunit}
C2   top bn1 {2*Cunit}
C1   top bn0 {1*Cunit}

* Dummy capacitor (always connected to GND)
Cdummy top gnd_node {1*Cunit}

* Bottom-plate switches using voltage-controlled switches
* sw=high -> bottom plate to Vref
* sw=low  -> bottom plate to GND
* Ron = 500 ohm (models transmission gate on-resistance)

* Bit 7 (MSB) - 128C
S7h  vref     bn7 sw7 gnd_node SWMOD
S7l  gnd_node bn7 sw7_n gnd_node SWMOD
E7inv sw7_n gnd_node vol='1.8-v(sw7)'

* Bit 6 - 64C
S6h  vref     bn6 sw6 gnd_node SWMOD
S6l  gnd_node bn6 sw6_n gnd_node SWMOD
E6inv sw6_n gnd_node vol='1.8-v(sw6)'

* Bit 5 - 32C
S5h  vref     bn5 sw5 gnd_node SWMOD
S5l  gnd_node bn5 sw5_n gnd_node SWMOD
E5inv sw5_n gnd_node vol='1.8-v(sw5)'

* Bit 4 - 16C
S4h  vref     bn4 sw4 gnd_node SWMOD
S4l  gnd_node bn4 sw4_n gnd_node SWMOD
E4inv sw4_n gnd_node vol='1.8-v(sw4)'

* Bit 3 - 8C
S3h  vref     bn3 sw3 gnd_node SWMOD
S3l  gnd_node bn3 sw3_n gnd_node SWMOD
E3inv sw3_n gnd_node vol='1.8-v(sw3)'

* Bit 2 - 4C
S2h  vref     bn2 sw2 gnd_node SWMOD
S2l  gnd_node bn2 sw2_n gnd_node SWMOD
E2inv sw2_n gnd_node vol='1.8-v(sw2)'

* Bit 1 - 2C
S1h  vref     bn1 sw1 gnd_node SWMOD
S1l  gnd_node bn1 sw1_n gnd_node SWMOD
E1inv sw1_n gnd_node vol='1.8-v(sw1)'

* Bit 0 (LSB) - 1C
S0h  vref     bn0 sw0 gnd_node SWMOD
S0l  gnd_node bn0 sw0_n gnd_node SWMOD
E0inv sw0_n gnd_node vol='1.8-v(sw0)'

* Switch model
.model SWMOD SW vt=0.9 vh=0.1 ron=500 roff=1G

.ends cap_dac_8b

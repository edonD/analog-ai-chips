* ============================================================
* VibroSense-1 Block 07: 8-bit SAR ADC
* Testbench: DNL / INL (code density histogram test)
* ============================================================
* Method: Apply slow ramp, use B-source to quantize to 8-bit code.
* The quantized code voltage is captured, then Python computes DNL/INL.
*
* B-sources (B-element) support the ternary ? operator in ngspice.
* We use a single-expression 8-bit quantizer via nested ternary.
* ============================================================

.option scale=1e-6
.option method=trap
.option abstol=1e-12 reltol=1e-4 vntol=1e-6

* ============================================================
* PARAMETERS
* ============================================================
.param VDD=1.8
.param VREF=1.2
.param Cunit=20f

* ============================================================
* SUPPLIES
* ============================================================
Vvdd  vdd  0  {VDD}
* Vgnd removed (gnd = node 0 = global ground, no source needed)
Vref  vref 0  {VREF}

* ============================================================
* SLOW RAMP INPUT: 0V to 1.2V in 25.6ms
* ============================================================
Vramp vin 0 PWL(0 0 25.6m 1.2 25.7m 1.2)

* ============================================================
* 8-BIT ADC BEHAVIORAL MODEL
* ============================================================
* Quantize vin to 8-bit integer code (0-255) stored as a voltage
* Using B-source with ternary comparison chain

* Step 1: Compute normalized input (0 to 1 range)
* v_norm = v(vin) / VREF, clamped to [0, 1)

* The 8-bit code as analog voltage (each count = 1V for easy reading)
* code_v = round(v(vin) / VREF * 255), expressed as staircase

* Use a staircase via B-source: compare input against each threshold
* Threshold for code k = (k + 0.5) × VREF / 256

* Rather than 256 comparisons, use binary search via 8 bits:
* bit7 (MSB): 1 if vin >= 0.5 × VREF
* bit6:       1 if (bit7=1 ? vin >= 0.75×VREF : vin >= 0.25×VREF)
* etc. — this is the SAR algorithm itself

* Simpler: use the thermometer code approach with B-source math
* B-source can do floor() via integer conversion trick:
* floor(x) = x - (x - int(x)) but ngspice int() is not available
* Use: nint(x) rounds to nearest integer

* NGSPICE B-source supports: nint(x) = round to nearest int
* So code = nint(v(vin)/VREF * 255.0)
* But we need floor, not round: use nint(x - 0.5) = floor(x) for x>0

* Method: code = nint(v(vin)/VREF * 255 - 0.4999)
* This is equivalent to floor() for uniform quantization

Bcode code 0 V = nint(v(vin)/VREF * 255.0 - 0.5001)

* Clamp to [0, 255]
Bcode_c code_c 0 V = (v(code) < 0) ? 0 : (v(code) > 255 ? 255 : v(code))

* Digital output bits (CMOS level: 0 or VDD)
* Using B-source with ternary comparisons against code
Bd7 d7 0 V = (v(code_c) >= 128) ? VDD : 0
Bd6 d6 0 V = (v(code_c) - 128*((v(code_c) >= 128) ? 1 : 0)) >= 64 ? VDD : 0
Bd5 d5 0 V = (v(code_c) - 128*((v(code_c) >= 128) ? 1 : 0) - 64*((v(code_c) - 128*((v(code_c) >= 128) ? 1 : 0)) >= 64 ? 1 : 0)) >= 32 ? VDD : 0
Bd4 d4 0 V = 0
Bd3 d3 0 V = 0
Bd2 d2 0 V = 0
Bd1 d1 0 V = 0
Bd0 d0 0 V = 0

* ============================================================
* SIMULATION
* ============================================================
.tran 2u 25.6m uic

.control
    run
    wrdata ./dnl_inl_raw.dat v(vin) v(code_c)
    echo "DNL/INL simulation complete."
    quit
.endc

.end

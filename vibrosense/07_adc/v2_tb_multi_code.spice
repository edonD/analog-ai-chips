* ============================================================================
* TB2: Multi-Code Verification — Transfer Function
* VibroSense 8-bit SAR ADC v2
* ============================================================================
* Run 13 conversions at different input voltages (0V to 1.2V in 0.1V steps)
* Verify monotonic transfer function with correct code mapping

.lib "sky130_v2_nosubckt.lib.spice" tt
.include "v2_strongarm_comp.spice"
.include "v2_cap_dac_8b.spice"
.include "v2_sar_logic.spice"

VDD vdd 0 1.8
VSS vss 0 0
Vref vref 0 1.2

* Input: step through 0V, 0.1V, 0.2V, ... 1.2V
* Each conversion takes ~100us (10 clocks at 10us/clock)
* Allow 120us per conversion for safety
* Total: 13 * 120us = 1560us = 1.56ms
Vin vin 0 PWL(
+ 0 0.0
+ 120u 0.0   120.01u 0.1
+ 240u 0.1   240.01u 0.2
+ 360u 0.2   360.01u 0.3
+ 480u 0.3   480.01u 0.4
+ 600u 0.4   600.01u 0.5
+ 720u 0.5   720.01u 0.6
+ 840u 0.6   840.01u 0.7
+ 960u 0.7   960.01u 0.8
+ 1080u 0.8  1080.01u 0.9
+ 1200u 0.9  1200.01u 1.0
+ 1320u 1.0  1320.01u 1.1
+ 1440u 1.1  1440.01u 1.2
+ 1600u 1.2)

* Clock: 100 kHz
Vclk clk 0 PULSE(0 1.8 5u 10n 10n 4.99u 10u)

* Convert: pulse every 120us
Vconv convert 0 PULSE(0 1.8 8u 10n 10n 14.99u 120u)

* Sample Switch
Msw_n vin sample vtop vss sky130_fd_pr__nfet_01v8__model w=5u l=0.15u
Msw_p vin sample_b vtop vdd sky130_fd_pr__pfet_01v8__model w=10u l=0.15u

* DAC
Xdac vtop vref vss
+ sw7 sw7b sw6 sw6b sw5 sw5b sw4 sw4b
+ sw3 sw3b sw2 sw2b sw1 sw1b sw0 sw0b
+ vdd vss v2_cap_dac_8b

* Comparator
X_comp vtop vref comp_outp comp_outn vdd vss comp_clk sleep_n v2_comparator
Vsleep sleep_n 0 1.8

* SAR Logic
Xsar clk convert comp_outn
+ sw7 sw6 sw5 sw4 sw3 sw2 sw1 sw0
+ sw7b sw6b sw5b sw4b sw3b sw2b sw1b sw0b
+ sample sample_b valid comp_clk
+ vdd vss v2_sar_logic

.tran 500n 1600u

.control
run

* Read codes when valid is asserted (approximately 110us after each convert)
echo "=== Transfer Function ==="
meas tran c0 FIND v(sw7) AT=112u
meas tran c1 FIND v(sw7) AT=232u
meas tran c2 FIND v(sw7) AT=352u
meas tran c3 FIND v(sw7) AT=472u
meas tran c4 FIND v(sw7) AT=592u
meas tran c5 FIND v(sw7) AT=712u
meas tran c6 FIND v(sw7) AT=832u
meas tran c7 FIND v(sw7) AT=952u
meas tran c8 FIND v(sw7) AT=1072u
meas tran c9 FIND v(sw7) AT=1192u
meas tran c10 FIND v(sw7) AT=1312u
meas tran c11 FIND v(sw7) AT=1432u
meas tran c12 FIND v(sw7) AT=1552u

wrdata v2_multi_code.dat v(sw7) v(sw6) v(sw5) v(sw4) v(sw3) v(sw2) v(sw1) v(sw0) v(valid) v(vtop) v(vin)

quit
.endc
.end

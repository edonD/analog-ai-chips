* ============================================================================
* TB8: Corner Simulation — Single Conversion at all 5 corners
* VibroSense 8-bit SAR ADC v2
* ============================================================================
* Uses .param for corner selection (run 5 times with different corners)
* Default: TT corner

.param corner_name = 1
* 1=tt, 2=ss, 3=ff, 4=sf, 5=fs

.if (corner_name == 1)
.lib "sky130_v2_nosubckt.lib.spice" fs
.elseif (corner_name == 2)
.lib "sky130_v2_nosubckt.lib.spice" ss
.elseif (corner_name == 3)
.lib "sky130_v2_nosubckt.lib.spice" ff
.elseif (corner_name == 4)
.lib "sky130_v2_nosubckt.lib.spice" sf
.elseif (corner_name == 5)
.lib "sky130_v2_nosubckt.lib.spice" fs
.endif

.include "v2_strongarm_comp.spice"
.include "v2_cap_dac_8b.spice"
.include "v2_sar_logic.spice"

VDD vdd 0 1.8
VSS vss 0 0
Vref vref 0 1.2
Vin vin 0 0.47

Vclk clk 0 PULSE(0 1.8 5u 10n 10n 4.99u 10u)
Vconv convert 0 PWL(0 0 8u 0 8.01u 1.8 20u 1.8 20.01u 0)

Msw_n vin sample vtop vss sky130_fd_pr__nfet_01v8__model w=5u l=0.15u
Msw_p vin sample_b vtop vdd sky130_fd_pr__pfet_01v8__model w=10u l=0.15u

Xdac vtop vref vss
+ sw7 sw7b sw6 sw6b sw5 sw5b sw4 sw4b
+ sw3 sw3b sw2 sw2b sw1 sw1b sw0 sw0b
+ vdd vss v2_cap_dac_8b

X_comp vtop vref comp_outp comp_outn vdd vss comp_clk sleep_n v2_comparator
Vsleep sleep_n 0 1.8

Xsar clk convert comp_outn
+ sw7 sw6 sw5 sw4 sw3 sw2 sw1 sw0
+ sw7b sw6b sw5b sw4b sw3b sw2b sw1b sw0b
+ sample sample_b valid comp_clk
+ vdd vss v2_sar_logic

.tran 100n 130u

.control
run
meas tran d7v FIND v(sw7) AT=112u
meas tran d6v FIND v(sw6) AT=112u
meas tran d5v FIND v(sw5) AT=112u
meas tran d4v FIND v(sw4) AT=112u
meas tran d3v FIND v(sw3) AT=112u
meas tran d2v FIND v(sw2) AT=112u
meas tran d1v FIND v(sw1) AT=112u
meas tran d0v FIND v(sw0) AT=112u
meas tran valid_v FIND v(valid) AT=112u
meas tran vtop_f FIND v(vtop) AT=110u
quit
.endc
.end

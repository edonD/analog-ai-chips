* v2 Comparator Standalone Verification
.lib "sky130_v2.lib.spice" tt
.include "v2_strongarm_comp.spice"

VDD vdd 0 1.8
VSS vss 0 0
Vsleep sleep_n 0 1.8

* Clock: 100 kHz
Vclk clk 0 PULSE(0 1.8 1u 1n 1n 4.5u 10u)

* Input: Vin+ = 0.60235V, Vin- = 0.59765V (1 LSB = 4.7 mV)
Vinp inp 0 0.60235
Vinn inn 0 0.59765

X1 inp inn outp outn vdd vss clk sleep_n v2_comparator

.tran 10n 50u

.control
run
meas tran vop_min MIN v(outp) FROM=5u TO=15u
meas tran von_min MIN v(outn) FROM=5u TO=15u
meas tran t_decision TRIG v(clk) val=0.9 rise=1 TARG v(outn) val=0.9 fall=1
meas tran Iavg AVG i(VDD) FROM=1u TO=50u
let Pavg = -Iavg * 1.8
print Pavg
quit
.endc
.end

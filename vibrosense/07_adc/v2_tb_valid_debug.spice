* Debug: check state machine progression and valid signal
.lib "sky130_v2_nosubckt.lib.spice" tt
.include "v2_strongarm_comp.spice"
.include "v2_cap_dac_8b.spice"
.include "v2_sar_logic.spice"
VDD vdd 0 1.8
VSS vss 0 0
Vref vref 0 1.2
Vin vin 0 0.47
Vclk clk 0 PULSE(0 1.8 5u 10n 10n 4.99u 10u)
Vconv convert 0 PWL(0 0 8u 0 8.01u 1.8 20u 1.8 20.01u 0)
Msw_n vin sample vtop vss sky130_fd_pr__nfet_01v8__model w=5u l=0.15u
Msw_p vin sample_b vtop vdd sky130_fd_pr__pfet_01v8__model w=10u l=0.15u
Xdac vtop vref vss
+ sw7 sw7b sw6 sw6b sw5 sw5b sw4 sw4b
+ sw3 sw3b sw2 sw2b sw1 sw1b sw0 sw0b
+ vdd vss v2_cap_dac_8b
X_comp vtop vref comp_outp comp_outn vdd vss comp_clk sleep_n v2_comparator
Vsleep sleep_n 0 1.8
Xsar clk convert comp_outn
+ sw7 sw6 sw5 sw4 sw3 sw2 sw1 sw0
+ sw7b sw6b sw5b sw4b sw3b sw2b sw1b sw0b
+ sample sample_b valid comp_clk
+ vdd vss v2_sar_logic

.tran 100n 130u

.control
run
* Check states (via DAC bit outputs as proxies)
echo "=== State progression ==="
meas tran samp_17 FIND v(sample) AT=17u
meas tran samp_27 FIND v(sample) AT=27u
meas tran val_100 FIND v(valid) AT=100u
meas tran val_110 FIND v(valid) AT=110u
meas tran val_115 FIND v(valid) AT=115u
meas tran val_120 FIND v(valid) AT=120u
* Check vtop at each bit evaluation
echo "=== VTop progression ==="
meas tran vt_20 FIND v(vtop) AT=20u
meas tran vt_27 FIND v(vtop) AT=27u
meas tran vt_37 FIND v(vtop) AT=37u
meas tran vt_47 FIND v(vtop) AT=47u
meas tran vt_57 FIND v(vtop) AT=57u
meas tran vt_67 FIND v(vtop) AT=67u
meas tran vt_77 FIND v(vtop) AT=77u
meas tran vt_87 FIND v(vtop) AT=87u
meas tran vt_97 FIND v(vtop) AT=97u
meas tran vt_107 FIND v(vtop) AT=107u
quit
.endc
.end

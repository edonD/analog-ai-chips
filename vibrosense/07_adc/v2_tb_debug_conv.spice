* Debug: trace state machine and comparator through conversion
.lib "sky130_v2_nosubckt.lib.spice" tt
.include "v2_strongarm_comp.spice"
.include "v2_cap_dac_8b.spice"
.include "v2_sar_logic.spice"

VDD vdd 0 1.8
VSS vss 0 0
Vref vref 0 1.2
Vin vin 0 0.47
Vclk clk 0 PULSE(0 1.8 5u 10n 10n 4.99u 10u)
Vconv convert 0 PWL(0 0 8u 0 8.01u 1.8 20u 1.8 20.01u 0)
Msw_n vin sample vtop vss sky130_fd_pr__nfet_01v8__model w=5u l=0.15u
Msw_p vin sample_b vtop vdd sky130_fd_pr__pfet_01v8__model w=10u l=0.15u
Xdac vtop vref vss
+ sw7 sw7b sw6 sw6b sw5 sw5b sw4 sw4b
+ sw3 sw3b sw2 sw2b sw1 sw1b sw0 sw0b
+ vdd vss v2_cap_dac_8b
X_comp vtop vref comp_outp comp_outn vdd vss comp_clk sleep_n v2_comparator
Vsleep sleep_n 0 1.8
Mlatch_n comp_outn comp_clk comp_held vss sky130_fd_pr__nfet_01v8__model w=2u l=0.15u
Mlatch_inv comp_clk_inv comp_clk vss vss sky130_fd_pr__nfet_01v8__model w=1u l=0.15u
Mlatch_inv2 comp_clk_inv comp_clk vdd vdd sky130_fd_pr__pfet_01v8__model w=2u l=0.15u
Mlatch_p comp_outn comp_clk_inv comp_held vdd sky130_fd_pr__pfet_01v8__model w=4u l=0.15u
Chold comp_held vss 100f
Rhold comp_held vss 100G
Xsar clk convert comp_held
+ sw7 sw6 sw5 sw4 sw3 sw2 sw1 sw0
+ sw7b sw6b sw5b sw4b sw3b sw2b sw1b sw0b
+ sample sample_b valid comp_clk
+ vdd vss v2_sar_logic

.tran 10n 60u

.control
run
* Check sample at 20us (should be HIGH during sample phase)
echo "=== Sample ==="
meas tran samp_12 FIND v(sample) AT=12u
meas tran samp_17 FIND v(sample) AT=17u
meas tran samp_22 FIND v(sample) AT=22u

echo "=== VTop ==="
meas tran vt_17 FIND v(vtop) AT=17u
meas tran vt_27 FIND v(vtop) AT=27u
meas tran vt_37 FIND v(vtop) AT=37u

echo "=== CompClk ==="
meas tran cc_17 FIND v(comp_clk) AT=17u
meas tran cc_27 FIND v(comp_clk) AT=27u
meas tran cc_32 FIND v(comp_clk) AT=32u

echo "=== CompOutN ==="
meas tran cn_27 FIND v(comp_outn) AT=27u
meas tran cn_32 FIND v(comp_outn) AT=32u

echo "=== CompHeld ==="
meas tran ch_32 FIND v(comp_held) AT=32u
meas tran ch_34 FIND v(comp_held) AT=34u

echo "=== Bits ==="
meas tran b7_27 FIND v(sw7) AT=27u
meas tran b7_37 FIND v(sw7) AT=37u
meas tran b6_37 FIND v(sw6) AT=37u
quit
.endc
.end

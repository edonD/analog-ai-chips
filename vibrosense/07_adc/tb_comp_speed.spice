* Comparator Offset and Speed Test
.include "sky130_pdk_fixup.spice"
.lib "sky130_minimal_v2.lib.spice" tt
.include "strongarm_comp.spice"

VDD vdd 0 1.8
Vsleep sleep_n 0 1.8

* Input: step from 0mV to 5mV differential at t=5us
Vinp inp 0 PWL(0 0.6 4.99u 0.6 5u 0.6025)
Vinn inn 0 0.5975

* Clock
Vclk clk 0 PULSE(0 1.8 5u 0.5n 0.5n 4.9u 10u)

X1 inp inn outp outn vdd 0 clk sleep_n comparator

.tran 0.5n 25u

.meas tran t_rise TRIG v(clk) VAL=0.9 RISE=1 TARG v(outp) VAL=0.9 RISE=1
.meas tran t_fall TRIG v(clk) VAL=0.9 RISE=1 TARG v(outn) VAL=0.9 FALL=1
.meas tran vout_high MAX v(outp) FROM=6u TO=9u
.meas tran vout_low MIN v(outn) FROM=6u TO=9u

.control
run
wrdata comp_speed_test.dat v(outp) v(outn) v(clk) v(inp) v(inn)
quit
.endc

.end

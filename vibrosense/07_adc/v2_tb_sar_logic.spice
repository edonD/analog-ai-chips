* SAR Logic Standalone Test — verify code 100 output
.lib "sky130_v2.lib.spice" tt
.include "v2_sar_logic.spice"

VDD vdd 0 1.8
VSS vss 0 0

* Clock: 100 kHz, rising edges at 5, 15, 25, 35, 45, 55, 65, 75, 85, 95, 105us
Vclk clk 0 PULSE(0 1.8 5u 10n 10n 4.99u 10u)

* Convert: HIGH from 10-20us
Vconv convert 0 PWL(0 0 10u 0 10.01u 1.8 20u 1.8 20.01u 0)

* Expected code: 100 = 01100100 (b7=0, b6=1, b5=1, b4=0, b3=0, b2=1, b1=0, b0=0)
* State timeline:
*   Edge 15us: enter s1 (SAMPLE)
*   Edge 25us: enter s2 (bit7 eval) — need comp=0 → clear bit7
*   Edge 35us: enter s3 (bit6 eval) — need comp=1 → keep bit6
*   Edge 45us: enter s4 (bit5 eval) — need comp=1 → keep bit5
*   Edge 55us: enter s5 (bit4 eval) — need comp=0 → clear bit4
*   Edge 65us: enter s6 (bit3 eval) — need comp=0 → clear bit3
*   Edge 75us: enter s7 (bit2 eval) — need comp=1 → keep bit2
*   Edge 85us: enter s8 (bit1 eval) — need comp=0 → clear bit1
*   Edge 95us: enter s9 (bit0 eval) — need comp=0 → clear bit0
*
* comp_d is latched at the NEXT edge after evaluation. So:
* bit7 result latched at 35us: comp during 25-35us should be LOW
* bit6 result latched at 45us: comp during 35-45us should be HIGH
* bit5 result latched at 55us: comp during 45-55us should be HIGH
* bit4 result latched at 65us: comp during 55-65us should be LOW
* bit3 result latched at 75us: comp during 65-75us should be LOW
* bit2 result latched at 85us: comp during 75-85us should be HIGH
* bit1 result latched at 95us: comp during 85-95us should be LOW
* bit0 result latched at 105us: comp during 95-105us should be LOW
*
* PWL: comp must be stable BEFORE each latch edge
* Transitions happen 1us after the latching edge (mid-state)
* bit7 latch@35us: comp LOW during 25-35us → stays 0
* bit6 latch@45us: comp HIGH during 35-45us → goes HIGH at 36us
* bit5 latch@55us: comp HIGH during 45-55us → stays HIGH
* bit4 latch@65us: comp LOW during 55-65us → goes LOW at 56us
* bit3 latch@75us: comp LOW during 65-75us → stays LOW
* bit2 latch@85us: comp HIGH during 75-85us → goes HIGH at 76us
* bit1 latch@95us: comp LOW during 85-95us → goes LOW at 86us
* bit0 latch@105us: comp LOW during 95-105us → stays LOW
Vcomp comp_out 0 PWL(
+ 0 0
+ 36u 0
+ 36.01u 1.8
+ 56u 1.8
+ 56.01u 0
+ 76u 0
+ 76.01u 1.8
+ 86u 1.8
+ 86.01u 0
+ 130u 0)

Xsar clk convert comp_out
+ d7 d6 d5 d4 d3 d2 d1 d0
+ d7b d6b d5b d4b d3b d2b d1b d0b
+ sample sample_b valid comp_clk
+ vdd vss
+ v2_sar_logic

.tran 100n 130u

.control
run
meas tran d7v FIND v(d7) AT=115u
meas tran d6v FIND v(d6) AT=115u
meas tran d5v FIND v(d5) AT=115u
meas tran d4v FIND v(d4) AT=115u
meas tran d3v FIND v(d3) AT=115u
meas tran d2v FIND v(d2) AT=115u
meas tran d1v FIND v(d1) AT=115u
meas tran d0v FIND v(d0) AT=115u
meas tran valv FIND v(valid) AT=110u
meas tran sampv FIND v(sample) AT=20u
* Expected: d7=0 d6=1.8 d5=1.8 d4=0 d3=0 d2=1.8 d1=0 d0=0 (code 100)
quit
.endc
.end

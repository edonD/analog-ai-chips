* Debug: check comparator during 40-45us (bit6 eval with inverted clk)
.lib "sky130_v2_nosubckt.lib.spice" tt
.include "v2_strongarm_comp.spice"
.include "v2_cap_dac_8b.spice"
.include "v2_sar_logic.spice"
VDD vdd 0 1.8
VSS vss 0 0
Vref vref 0 1.2
Vin vin 0 0.47
Vclk clk 0 PULSE(0 1.8 5u 10n 10n 4.99u 10u)
Vconv convert 0 PWL(0 0 8u 0 8.01u 1.8 20u 1.8 20.01u 0)
Msw_n vin sample vtop vss sky130_fd_pr__nfet_01v8__model w=5u l=0.15u
Msw_p vin sample_b vtop vdd sky130_fd_pr__pfet_01v8__model w=10u l=0.15u
Xdac vtop vref vss
+ sw7 sw7b sw6 sw6b sw5 sw5b sw4 sw4b
+ sw3 sw3b sw2 sw2b sw1 sw1b sw0 sw0b
+ vdd vss v2_cap_dac_8b
Xlatch vtop vref comp_outp comp_outn vdd vss comp_clk v2_strongarm_latch
Mlatch_n comp_outn comp_clk comp_held vss sky130_fd_pr__nfet_01v8__model w=2u l=0.15u
Mlatch_inv comp_clk_inv comp_clk vss vss sky130_fd_pr__nfet_01v8__model w=1u l=0.15u
Mlatch_inv2 comp_clk_inv comp_clk vdd vdd sky130_fd_pr__pfet_01v8__model w=2u l=0.15u
Mlatch_p comp_outn comp_clk_inv comp_held vdd sky130_fd_pr__pfet_01v8__model w=4u l=0.15u
Chold comp_held vss 100f
Rhold comp_held vss 100G
Xsar clk convert comp_held
+ sw7 sw6 sw5 sw4 sw3 sw2 sw1 sw0
+ sw7b sw6b sw5b sw4b sw3b sw2b sw1b sw0b
+ sample sample_b valid comp_clk
+ vdd vss v2_sar_logic

.tran 0.5n 50u

.control
run
echo "=== bit6 eval: inverted clk, should be 40-45us ==="
meas tran cc_39 FIND v(comp_clk) AT=39u
meas tran cc_41 FIND v(comp_clk) AT=41u
meas tran cc_43 FIND v(comp_clk) AT=43u
meas tran vt_41 FIND v(vtop) AT=41u
meas tran cn_41 FIND v(comp_outn) AT=41u
meas tran cp_41 FIND v(comp_outp) AT=41u
meas tran cn_43 FIND v(comp_outn) AT=43u
meas tran cp_43 FIND v(comp_outp) AT=43u
echo "=== comp_held around edge 45us ==="
meas tran ch_44 FIND v(comp_held) AT=44u
meas tran ch_44_9 FIND v(comp_held) AT=44.99u
meas tran ch_45_1 FIND v(comp_held) AT=45.01u
echo "=== bit6 output ==="
meas tran b6_46 FIND v(sw6) AT=46u
quit
.endc
.end

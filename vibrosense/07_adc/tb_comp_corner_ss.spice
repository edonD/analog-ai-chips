* Comparator Corner Test — SS/85C
.include "sky130_pdk_fixup.spice"
.lib "sky130_minimal_v2.lib.spice" ss
.include "strongarm_comp.spice"

VDD vdd 0 1.8
Vsleep sleep_n 0 1.8
Vinp inp 0 0.605
Vinn inn 0 0.600
Vclk clk 0 PULSE(0 1.8 0 0.5n 0.5n 4.9u 10u)

X1 inp inn outp outn vdd 0 clk sleep_n comparator

.option temp=85
.tran 0.5n 25u

.meas tran vout_diff FIND 'v(outp)-v(outn)' AT=9u
.meas tran Iavg AVG I(VDD) FROM=0 TO=20u

.control
run
quit
.endc

.end

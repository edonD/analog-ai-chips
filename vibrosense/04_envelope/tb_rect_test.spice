* TB: Envelope Detector v2 — Basic Rectifier Test
* 100mVpp sine at 3162Hz, check full-wave rectification
.option scale=1e-6
.lib "sky130_minimal_v2.lib.spice" tt
.include "ota_pga_v2.spice"
.include "envelope_det.spice"

.param vdd_val = 1.8
.param vcm_val = 0.9
.param amp_val = 50m
.param freq_val = 3162

* Supply
Vdd vdd 0 dc {vdd_val}

* Self-biasing vbn — same as OTA v2 testbench
Ibias_n vdd vbn dc 1500n
Xbias_n vbn vbn 0 0 sky130_fd_pr__nfet_01v8 w=11.4 l=14 nf=1
Cbn vbn 0 100p

* LPF bias — very low current for ~10 Hz cutoff
Ibias_lpf vdd vbn_lpf dc 100n
Xbias_lpf vbn_lpf vbn_lpf 0 0 sky130_fd_pr__nfet_01v8 w=1 l=8 nf=1
Cbn_lpf vbn_lpf 0 100p

* Input: 100mVpp sine centered on VCM
Vin vin 0 sin({vcm_val} {amp_val} {freq_val})
Vcm vcm 0 dc {vcm_val}

* DUT
Xenv vin vcm vout vdd 0 vbn vbn_lpf envelope_det

.tran 1u 500m

.control
run

* Measure from 300-500ms (LPF needs settling time)
meas tran vout_avg AVG v(vout) from=300m to=500m
meas tran vout_min MIN v(vout) from=300m to=500m
meas tran vout_max MAX v(vout) from=300m to=500m
meas tran rect_avg AVG v(xenv.rect) from=300m to=500m
meas tran rect_min MIN v(xenv.rect) from=300m to=500m
meas tran rect_max MAX v(xenv.rect) from=300m to=500m
meas tran oa1_min MIN v(xenv.xrect.oa1) from=300m to=500m
meas tran oa1_max MAX v(xenv.xrect.oa1) from=300m to=500m
meas tran oa2_min MIN v(xenv.xrect.oa2) from=300m to=500m
meas tran oa2_max MAX v(xenv.xrect.oa2) from=300m to=500m

let rect_pp = rect_max - rect_min
let vout_pp = vout_max - vout_min

echo "=== Envelope Detector v2 Basic Test ==="
echo "rect_avg = $&rect_avg"
echo "rect_min = $&rect_min"
echo "rect_max = $&rect_max"
echo "rect_pp  = $&rect_pp"
echo "vout_avg = $&vout_avg"
echo "vout_min = $&vout_min"
echo "vout_max = $&vout_max"
echo "vout_pp  = $&vout_pp"
echo "oa1 range = $&oa1_min to $&oa1_max"
echo "oa2 range = $&oa2_min to $&oa2_max"

* Power measurement
meas tran idd AVG i(Vdd) from=300m to=500m
let pwr = -idd * 1.8 * 1e6
echo "power_uw = $&pwr"

quit
.endc
.end

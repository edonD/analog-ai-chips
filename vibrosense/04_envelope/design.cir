* VibroSense Block 04: Envelope Detector — SKY130A
* Full-wave OTA-based precision rectifier + Gm-C Low-Pass Filter
*
* Architecture:
*   Stage 1: Two half-wave rectifiers (OTA + diode) summed for full-wave
*            Each OTA outputs gm*(Vdiff), MOSFET diode clips negative current
*   Stage 2: First-order Gm-C LPF (fc ~ 100 Hz) smooths to DC envelope
*
* Ports:
*   vin  - Input signal (from BPF output, AC on top of VCM)
*   vcm  - Common-mode reference voltage (0.9V)
*   vout - DC envelope output
*   vdd  - Supply (1.8V)
*   vss  - Ground (0V)
*
* Design targets:
*   Rectification accuracy: <5% at 100mVpp, <15% at 10mVpp
*   LPF cutoff: 100 Hz (50-150 Hz acceptable for fast settling)
*   Output ripple: <10% of DC at BPF3 frequency (relaxed for speed)
*   Settling time: <10 ms (10% to 90%)
*   Power per channel: <10 uW

* ============================================================
* BEHAVIORAL MODEL (v1) — for initial spec verification
* Uses B-sources to model OTA + diode rectification
* Replace with transistor-level OTAs from Block 01 when available
* ============================================================

.subckt envelope_det vin vcm vout vdd vss

* --- Design Parameters ---
* Rectifier OTA: gm = 2.5 uA/V (matches Block 01 OTA at Ibias=500nA)
* LPF OTA: gm = 6.28 nS (for fc=100 Hz with C=10pF)
* LPF cap: 10 pF (reduced from 100pF to speed up settling)

* === Stage 1: Full-Wave Precision Rectifier ===
*
* Two behavioral OTAs, each with a "diode" on its output:
*   max(0, gm*Vdiff) models OTA current through a diode-connected MOSFET
*   that only passes current in one direction.
*
* In a real implementation:
*   - Each OTA is a folded-cascode (Block 01) biased at ~200 nA
*   - Diode is a diode-connected PMOS between VDD and output
*   - When OTA drives low, PMOS conducts (charges output)
*   - When OTA drives high, PMOS cuts off (holds output)

* Half-wave 1: positive half-cycles (vin > vcm)
* Current flows from vss INTO rect node (charges it positive)
B_hw1 vss rect I = max(0, 2.5e-6 * (v(vin) - v(vcm)))

* Half-wave 2: negative half-cycles (vcm > vin)
B_hw2 vss rect I = max(0, 2.5e-6 * (v(vcm) - v(vin)))

* Combined current: I = gm * |vin - vcm| (full-wave rectified)
* Load resistor converts current to voltage
* R = 1/gm = 400 kOhm → V(rect) = |vin - vcm| (unity gain)
R_rect rect vss 400k

* Parasitic cap for numerical stability
C_rect rect vss 10f

* === Stage 2: Gm-C Low-Pass Filter ===
*
* First-order LPF: H(s) = 1 / (1 + s*C/gm)
* fc = gm / (2*pi*C) = 6.28e-9 / (2*pi*10e-12) = 100.0 Hz
* CHANGED: C reduced from 100pF to 10pF, fc raised from 10Hz to 100Hz
* Settling time: ~5*tau = 5/(2*pi*100) ~ 8ms (was ~80ms at 10Hz)
*
* In real implementation: simple 5-transistor OTA with Ibias ~ 20 nA
* Low gm achieved by very low bias current

* Current from vss INTO vout: charges vout toward v(rect)
G_lpf vss vout cur='6.28e-9 * (v(rect) - v(vout))'
C_lpf vout vss 10p

* High-value leakage resistor (sets DC bias, negligible at signal freq)
R_leak vout vss 100G

.ends envelope_det

* ============================================================
* TRANSISTOR-LEVEL RECTIFIER (v2) — for future use
* Uses SKY130 NMOS differential pair + PMOS current mirrors
* ============================================================
* TODO: Replace behavioral model with transistor-level when
* Block 01 OTA integration is complete. The key change is:
* - B_hw1/B_hw2 → real OTA subcircuits with MOSFET diodes
* - G_lpf → real OTA with very low bias current (~20 nA)
* - R_rect → implicit from OTA output impedance

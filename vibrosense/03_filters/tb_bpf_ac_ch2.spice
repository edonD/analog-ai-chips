* TB1: AC Sweep — Channel 2 (500-2000 Hz, f0=1000 Hz, Q=0.67)
.include bpf_ch2.spice

Vdd vdd 0 1.8
Vss vss 0 0
Vcm vcm 0 0.9
Vin in 0 DC 0.9 AC 1

Xbpf in bp_out vdd vss vcm bpf_ch2

.control
ac dec 500 1 100k
wrdata ac_ch2.txt v(bp_out)
.endc
.end

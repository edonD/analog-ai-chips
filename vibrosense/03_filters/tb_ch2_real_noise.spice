* TB6: Noise Analysis — Ch2 with REAL transistor-level OTA
* Uses ngspice .noise with real SKY130 device models
* Measures output noise spectral density and integrated noise

.lib "../01_ota/sky130_minimal.lib.spice" tt
.include "../01_ota/ota_foldcasc.spice"
.include "bpf_ch2_real.spice"

Vdd vdd 0 dc 1.8
Vbn  vbn  0 dc 0.565
Vbcn vbcn 0 dc 0.795
Vbp  vbp  0 dc 0.860
Vbcp vbcp 0 dc 0.605
Vcm vcm 0 dc 0.9

Vin in 0 dc 0.9 ac 0
Vss vss 0 dc 0

* DUT
Xbpf in bp_out vdd vss vcm vbn vbcn vbp vbcp bpf_ch2_real

.nodeset v(xbpf.int1)=0.9 v(xbpf.int2)=0.9

.control
* Noise analysis: output noise at bp_out, input source is Vin
noise v(bp_out) Vin dec 50 1 100k

* Print integrated noise
print onoise_total
print inoise_total

* Write noise spectrum
wrdata ch2_real_noise.txt onoise_spectrum

.endc
.end

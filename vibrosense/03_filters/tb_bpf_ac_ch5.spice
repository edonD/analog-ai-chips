* TB1: AC Sweep — Channel 5 (10-20 kHz, f0=14142 Hz, Q=1.41)
.include bpf_ch5.spice

Vdd vdd 0 1.8
Vss vss 0 0
Vcm vcm 0 0.9
Vin in 0 DC 0.9 AC 1

Xbpf in bp_out vdd vss vcm bpf_ch5

.control
ac dec 500 1 200k
wrdata ac_ch5.txt v(bp_out)
.endc
.end

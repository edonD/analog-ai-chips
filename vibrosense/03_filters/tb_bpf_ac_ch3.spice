* TB1: AC Sweep — Channel 3 (2-5 kHz, f0=3162 Hz, Q=1.05)
.include bpf_ch3.spice

Vdd vdd 0 1.8
Vss vss 0 0
Vcm vcm 0 0.9
Vin in 0 DC 0.9 AC 1

Xbpf in bp_out vdd vss vcm bpf_ch3

.control
ac dec 500 1 100k
wrdata ac_ch3.txt v(bp_out)
.endc
.end

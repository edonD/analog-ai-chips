* Test Ch2 filter with REAL bias generator from Block 00
* The bias generator auto-tracks PVT, providing correct bias at all corners

.lib "/home/ubuntu/pdk/sky130A/libs.tech/ngspice/sky130.lib.spice" tt
.include "../01_ota/ota_foldcasc.spice"
.include "../00_bias/bias_distribution/design_full.cir"

.option scale=1e-6

Vdd vdd 0 dc 1.8
Vgnd gnd 0 dc 0

* Bias generator instance
Xbias vdd gnd iref_out vbn vbcn vbp vbcp bias_generator_full

* Common mode
Vcm vcm 0 dc 0.9

* Input
Vin in 0 dc 0.9 ac 1

* Ch2 filter (inline, using bias gen outputs)
* At default bias (~2.12µS gm), f0=1000Hz needs sqrt(C1*C2)≈337pF
* With Q=0.67: C1 = 337p × 0.67 = 226pF, C2 = 337p / 0.67 = 503pF
* Pre-compensate for ~15pF parasitic at V1, ~8pF at V2:
* Target C1_eff=226p → C1_explicit=211p
* Target C2_eff=503p → C2_explicit=495p
Xota1 in int2 int1 vdd gnd vbn vbcn vbp vbcp ota_foldcasc
C1 int1 gnd 211p
Rbias1 int1 vcm 1G

Xota2 int1 vcm int2 vdd gnd vbn vbcn vbp vbcp ota_foldcasc
C2 int2 gnd 495p
Rbias2 int2 vcm 1G

Xota3 vcm int1 int1 vdd gnd vbn vbcn vbp vbcp ota_foldcasc

.nodeset v(int1)=0.9 v(int2)=0.9

.control
op
echo "=== Bias Generator Outputs ==="
print v(vbn) v(vbcn) v(vbp) v(vbcp)
echo "=== Filter DC ==="
print v(int1) v(int2)
let isup = -i(vdd)
echo "Total supply:"
print isup

ac dec 200 10 100k
wrdata ch2_biasgen_ac.txt vdb(int1)
.endc
.end

* BLOCKER 4: THD — Ch2 f0=1001.4Hz, 200mVpp diff
.lib "../01_ota/sky130_minimal.lib.spice" tt
.include "../01_ota/ota_foldcasc.spice"
.include "pseudo_res.spice"

Vdd vdd 0 dc 1.8
Vcm vcm 0 dc 0.9

Vvbn vbn 0 dc 0.5973
Vvbp vbp 0 dc 0.81
Vvbcn vbcn 0 dc 0.8273
Vvbcp vbcp 0 dc 0.555

* Differential sinusoidal input: 200mVpp = +/-50mV around 0.9V
Vinp vinp 0 SIN(0.9 0.05 1001.4)
Vinn vinn 0 SIN(0.9 -0.05 1001.4)

* Positive path
Xota1p vinp int2p int1p vdd 0 vbn vbcn vbp vbcp ota_foldcasc
C1p int1p 0 118.0p
Xpr1p int1p vcm pseudo_res
Xota2p int1p vcm int2p vdd 0 vbn vbcn vbp vbcp ota_foldcasc
C2p int2p 0 260.0p
Xpr2p int2p vcm pseudo_res
Xota3p vcm int1p int1p vdd 0 vbn vbcn vbp vbcp ota_foldcasc

* Negative path
Xota1n vinn int2n int1n vdd 0 vbn vbcn vbp vbcp ota_foldcasc
C1n int1n 0 118.0p
Xpr1n int1n vcm pseudo_res
Xota2n int1n vcm int2n vdd 0 vbn vbcn vbp vbcp ota_foldcasc
C2n int2n 0 260.0p
Xpr2n int2n vcm pseudo_res
Xota3n vcm int1n int1n vdd 0 vbn vbcn vbp vbcp ota_foldcasc

.nodeset v(int1p)=0.9 v(int2p)=0.9
+ v(int1n)=0.9 v(int2n)=0.9

.control
tran 1e-06 0.03496504893149591 0 uic
* Save differential output for FFT analysis
let vdiff = v(int1p) - v(int1n)
wrdata /home/ubuntu/analog-ai-chips/vibrosense/03_filters/b4_thd_ch2.txt vdiff
.endc
.end

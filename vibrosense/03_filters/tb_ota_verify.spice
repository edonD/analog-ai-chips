* Quick OTA verification with real SKY130 PDK
* Confirm the folded-cascode OTA simulates and has reasonable gain/GBW

.lib "../01_ota/sky130_minimal.lib.spice" tt
.include "../01_ota/ota_foldcasc.spice"

Vdd vdd 0 dc 1.8
Vbn  vbn  0 dc 0.65
Vbcn vbcn 0 dc 0.88
Vbp  vbp  0 dc 0.73
Vbcp vbcp 0 dc 0.475

* Input
Vinp vinp 0 dc 0.9 ac 1

* Loop-breaking
Lbreak vout vinn 1G
Cdc vinn 0 1

* OTA instance
Xota vinp vinn vout vdd 0 vbn vbcn vbp vbcp ota_foldcasc
CL vout 0 10p

.control
op
echo "=== DC Operating Point ==="
print v(vout) v(vinp) v(vinn)
print @vdd[i]

ac dec 100 0.1 1Meg
meas ac gain_peak MAX vdb(vout)
meas ac ugb WHEN vdb(vout)=0 FALL=1

echo "=== AC Results ==="
echo "Gain (dB):"
print gain_peak
echo "UGB (Hz):"
print ugb

wrdata ota_verify_ac.txt vdb(vout) vp(vout)
.endc

.end

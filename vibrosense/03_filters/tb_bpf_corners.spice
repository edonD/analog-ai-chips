* TB5: Corner and Temperature Sweep (untuned, DAC code=8)
* Documents f0/Q/gain variation across 15 PVT conditions
* Run via Python (analyze_tb5.py) which sweeps gm_scale for each PVT

.include bpf_ch1.spice

Vdd vdd 0 1.8
Vss vss 0 0
Vcm vcm 0 0.9
Vin in 0 DC 0.9 AC 1

.param gm_sc = 1.0
Xbpf in bp_out vdd vss vcm bpf_ch1 gm_scale={gm_sc}

.control
ac dec 300 1 200k
wrdata corners_sweep.txt v(bp_out)
.endc

.end

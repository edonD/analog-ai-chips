* Pseudo-differential BPF tuning — Ch4
.lib "../01_ota/sky130_minimal.lib.spice" tt
.include "../01_ota/ota_foldcasc.spice"
.include "pseudo_res.spice"

Vdd vdd 0 dc 1.8
Vbn vbn 0 dc 0.6399
Vbcn vbcn 0 dc 0.8699
Vbp vbp 0 dc 0.745
Vbcp vbcp 0 dc 0.49
Vcm vcm 0 dc 0.9

Vinp inp 0 dc 0.9 ac 0.5
Vinn inn 0 dc 0.9 ac -0.5

* Positive path
Xota1p inp int2p int1p vdd 0 vbn vbcn vbp vbcp ota_foldcasc
C1p int1p 0 59.0p
Xpr1p int1p vcm pseudo_res
Xota2p int1p vcm int2p vdd 0 vbn vbcn vbp vbcp ota_foldcasc
C2p int2p 0 29.7p
Xpr2p int2p vcm pseudo_res
Xota3p vcm int1p int1p vdd 0 vbn vbcn vbp vbcp ota_foldcasc

* Negative path
Xota1n inn int2n int1n vdd 0 vbn vbcn vbp vbcp ota_foldcasc
C1n int1n 0 59.0p
Xpr1n int1n vcm pseudo_res
Xota2n int1n vcm int2n vdd 0 vbn vbcn vbp vbcp ota_foldcasc
C2n int2n 0 29.7p
Xpr2n int2n vcm pseudo_res
Xota3n vcm int1n int1n vdd 0 vbn vbcn vbp vbcp ota_foldcasc

.nodeset v(int1p)=0.9 v(int2p)=0.9 v(int1n)=0.9 v(int2n)=0.9

.control
op
ac dec 200 353.55 141420
wrdata /home/ubuntu/analog-ai-chips/vibrosense/03_filters/tune_ch4_iter.txt vdb(int1p,int1n)
.endc
.end

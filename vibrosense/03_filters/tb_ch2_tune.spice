* Iterative C tuning for Ch2 real filter
* Goal: find C1, C2 that give f0=1000Hz, Q=0.67

.lib "../01_ota/sky130_minimal.lib.spice" tt
.include "../01_ota/ota_foldcasc.spice"

Vdd vdd 0 dc 1.8
Vbn  vbn  0 dc 0.565
Vbcn vbcn 0 dc 0.795
Vbp  vbp  0 dc 0.860
Vbcp vbcp 0 dc 0.605
Vcm vcm 0 dc 0.9
Vin in 0 dc 0.9 ac 1

* Parameterized filter (inline, not subckt, for easy param sweep)
.param c1_val = 55p
.param c2_val = 145p

Xota1 in int2 int1 vdd 0 vbn vbcn vbp vbcp ota_foldcasc
C1 int1 0 {c1_val}
Rbias1 int1 vcm 1G

Xota2 int1 vcm int2 vdd 0 vbn vbcn vbp vbcp ota_foldcasc
C2 int2 0 {c2_val}
Rbias2 int2 vcm 1G

Xota3 vcm int1 int1 vdd 0 vbn vbcn vbp vbcp ota_foldcasc

.nodeset v(int1)=0.9 v(int2)=0.9

.control
* Try several C combinations
* Iteration A: C1=55p, C2=145p
op
ac dec 200 10 100k
wrdata ch2_tune_A.txt vdb(int1)

* Iteration B: C1=50p, C2=140p
alter c1 50p
alter c2 140p
op
ac dec 200 10 100k
wrdata ch2_tune_B.txt vdb(int1)

* Iteration C: C1=60p, C2=148p
alter c1 60p
alter c2 148p
op
ac dec 200 10 100k
wrdata ch2_tune_C.txt vdb(int1)

* Iteration D: C1=45p, C2=135p
alter c1 45p
alter c2 135p
op
ac dec 200 10 100k
wrdata ch2_tune_D.txt vdb(int1)

.endc
.end

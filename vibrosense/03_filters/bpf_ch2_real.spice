* VibroSense Block 03 — Channel 2 Pseudo-Differential BPF
* f0=1000Hz, Q=0.67, Iref=200nA
* Tuned: C1=118.0pF C2=260.0pF → f0=1001.4Hz Q=0.707 pk=0.37dB
* Bias: VBN=0.5973 VBP=0.81 VBCN=0.8273 VBCP=0.555

.subckt bpf_ch2_real vinp vinn bp_outp bp_outn vdd vss vcm vbn vbcn vbp vbcp

* Positive path
Xota1p vinp int2p int1p vdd vss vbn vbcn vbp vbcp ota_foldcasc
C1p int1p vss 118.0p
Xpr1p int1p vcm pseudo_res
Xota2p int1p vcm int2p vdd vss vbn vbcn vbp vbcp ota_foldcasc
C2p int2p vss 260.0p
Xpr2p int2p vcm pseudo_res
Xota3p vcm int1p int1p vdd vss vbn vbcn vbp vbcp ota_foldcasc

* Negative path
Xota1n vinn int2n int1n vdd vss vbn vbcn vbp vbcp ota_foldcasc
C1n int1n vss 118.0p
Xpr1n int1n vcm pseudo_res
Xota2n int1n vcm int2n vdd vss vbn vbcn vbp vbcp ota_foldcasc
C2n int2n vss 260.0p
Xpr2n int2n vcm pseudo_res
Xota3n vcm int1n int1n vdd vss vbn vbcn vbp vbcp ota_foldcasc

* Differential output
Routp bp_outp int1p 1m
Routn bp_outn int1n 1m

.ends bpf_ch2_real

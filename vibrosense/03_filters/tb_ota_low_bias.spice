* Try to get OTA working at very low bias (for Ch1)
* The issue at L4/L5 was likely PMOS/NMOS current mismatch
* Try more aggressive Vbp increase and careful Vbcn/Vbcp adjustment

.lib "../01_ota/sky130_minimal.lib.spice" tt
.include "../01_ota/ota_foldcasc.spice"

Vdd vdd 0 dc 1.8
.param vbn_p = 0.604
.param vbp_p = 0.776

Vbn  vbn  0 dc {vbn_p}
Vbcn vbcn 0 dc 0.834
Vbp  vbp  0 dc {vbp_p}
Vbcp vbcp 0 dc 0.521

Vinp vinp 0 dc 0.9 ac 1
Lbreak vout vinn 1G
Cdc vinn 0 1
Xota vinp vinn vout vdd 0 vbn vbcn vbp vbcp ota_foldcasc
CL vout 0 10p

.control
* Try several combos around L3 going lower
* L3b: a bit lower than L3
alter vbn 0.595
alter vbp 0.790
alter vbcn 0.825
alter vbcp 0.530
op
echo "Vout:"
print v(vout)
echo "Isupply:"
print -i(vdd)
ac dec 100 0.01 200k
meas ac ugb3b WHEN vdb(vout)=0 FALL=1
let gm3b = ugb3b * 2 * 3.14159 * 10e-12
echo "L3b: UGB=$&ugb3b gm=$&gm3b"

alter vbn 0.585
alter vbp 0.800
alter vbcn 0.815
alter vbcp 0.540
op
echo "Vout:"
print v(vout)
echo "Isupply:"
print -i(vdd)
ac dec 100 0.01 200k
meas ac ugb3c WHEN vdb(vout)=0 FALL=1
let gm3c = ugb3c * 2 * 3.14159 * 10e-12
echo "L3c: UGB=$&ugb3c gm=$&gm3c"

alter vbn 0.575
alter vbp 0.810
alter vbcn 0.805
alter vbcp 0.550
op
echo "Vout:"
print v(vout)
echo "Isupply:"
print -i(vdd)
ac dec 100 0.001 100k
meas ac ugb3d WHEN vdb(vout)=0 FALL=1
let gm3d = ugb3d * 2 * 3.14159 * 10e-12
echo "L3d: UGB=$&ugb3d gm=$&gm3d"

alter vbn 0.565
alter vbp 0.820
alter vbcn 0.795
alter vbcp 0.560
op
echo "Vout:"
print v(vout)
echo "Isupply:"
print -i(vdd)
ac dec 100 0.001 50k
meas ac ugb3e WHEN vdb(vout)=0 FALL=1
let gm3e = ugb3e * 2 * 3.14159 * 10e-12
echo "L3e: UGB=$&ugb3e gm=$&gm3e"

.endc
.end

* TB4: CRITICAL — Tuning Range Verification across PVT
* Sweep DAC codes 1-15 at each of 15 PVT conditions (5 corners × 3 temps)
* PROVE: 4-bit DAC can compensate ±50% PVT-induced f0 shift to within ±10%
*
* PVT modeling for behavioral OTA:
*   gm_effective = gm_nominal × gm_pvt_factor × (dac_code / 8)
*   gm_pvt_factor models process + temperature effects on transconductance
*
* Run via Python script (analyze_tb4.py) which sweeps parameters

.include bpf_ch1.spice

Vdd vdd 0 1.8
Vss vss 0 0
Vcm vcm 0 0.9
Vin in 0 DC 0.9 AC 1

* Channel instantiated with gm_scale parameter
* gm_scale = pvt_factor × dac_code / 8
.param gm_sc = 1.0
Xbpf in bp_out vdd vss vcm bpf_ch1 gm_scale={gm_sc}

.control
ac dec 200 1 100k
wrdata tuning_sweep.txt v(bp_out)
.endc

.end

* TB: AC Sweep — Channel 2 BPF with REAL transistor-level OTA
* Bias level L3b: Vbn=0.595 Vbp=0.790 Vbcn=0.825 Vbcp=0.530
* f0=1000Hz, Q=0.67, C1=69.7pF, C2=155.4pF
* Q set by C ratio: Q = sqrt(C1/C2) = sqrt(69.7/155.4) = 0.67
* f0 = gm/sqrt(C1*C2) where gm ≈ 654nS

.lib "../01_ota/sky130_minimal.lib.spice" tt
.include "../01_ota/ota_foldcasc.spice"
.include "bpf_ch2_real.spice"

Vdd vdd 0 dc 1.8
Vss vss 0 dc 0

* Bias: LE level (calibrated balanced point)
Vbn  vbn  0 dc 0.565
Vbcn vbcn 0 dc 0.795
Vbp  vbp  0 dc 0.860
Vbcp vbcp 0 dc 0.605

Vcm vcm 0 dc 0.9
Vin in 0 dc 0.9 ac 1

* Initial conditions to help DC convergence with high Rbias
.nodeset v(xbpf.int1)=0.9 v(xbpf.int2)=0.9

* DUT: Ch2 BPF
Xbpf in bp_out vdd vss vcm vbn vbcn vbp vbcp bpf_ch2_real

.control
op
echo "=== DC OP ==="
print v(bp_out) v(xbpf.int1) v(xbpf.int2)
let isup = -i(vdd)
echo "Supply current (A):"
print isup
let pwr = isup * 1.8
echo "Power (W):"
print pwr

ac dec 200 10 100k
wrdata ch2_real_ac.txt vdb(bp_out) vp(bp_out)
.endc
.end

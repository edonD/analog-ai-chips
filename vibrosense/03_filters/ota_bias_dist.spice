* OTA-Matched Bias Distribution Network (v8)
* Generates VBN/VBP/VBCN/VBCP from Iref.
*
* VBN: Diode NMOS (W=3.8u L=14u, matched to OTA tail)
* VBP: Determined by OTA replica in unity-gain feedback (self-calibrating)
* VBCN: VBN + 0.23V offset
* VBCP: VBP - 0.255V offset
*
* The VBP generation uses an OTA replica in unity-gain (vinp=vinn=vcm=0.9V).
* The OTA's negative feedback naturally settles VBP to the correct value
* by pulling the output toward Vcm. This is a self-biasing approach:
* a dedicated OTA instance generates VBP that balances the fold current.
*
* Implementation: Use a dedicated OTA as a "bias OTA" in diode config.
* Its internal bias voltages track because it uses the same VBN.
* We extract VBP from the PMOS fold's gate inside this OTA... but
* we can't access internal nodes of the OTA subcircuit.
*
* ALTERNATIVE: Use a simple feedback loop. An OTA compares the replica
* output to Vcm and adjusts VBP through a PMOS driver.
*
* SIMPLEST: Accept that VBP must be externally calibrated per Iref level.
* Use a lookup table (implemented as a parameterized voltage source).
* The DAC code determines Iref which determines VBP. In silicon, this
* would use a replica bias with feedback.
*
* For simulation: VBP is a function of VBN (which tracks PVT).
* Empirically: VBP ≈ 1.8 - 0.92 = 0.88V at VBN=0.54 (70nA)
*              VBP ≈ 1.8 - 1.07 = 0.73V at VBN=0.65 (500nA)
*              VBP ≈ 1.8 - 0.94 = 0.86V at VBN=0.565 (218nA)
* Pattern: VBP = 0.88V at low current, 0.73V at high current
* Linear approximation: VBP ≈ 1.42 - 1.06 × VBN

.subckt ota_bias_dist iref vdd vss vbn vbcn vbp vbcp

* === VBN: Iref through diode NMOS ===
XMbn vbn vbn vss vss sky130_fd_pr__nfet_01v8 W=3.8u L=14u nf=1
Rlink iref vbn 1

* === VBP: Linear function of VBN ===
* VBP ≈ 1.42 - 1.06 × VBN (empirical fit from calibration data)
* Behavioral voltage source implements this
* Calibrated: VBP = 1.623 - 1.376 × VBN
* (fit from measured balance points: VBN=0.54→VBP=0.88, VBN=0.65→VBP=0.73)
Bvbp vbp vss V = 1.623 - 1.376 * v(vbn)

* === VBCN: VBN + 0.23V ===
Voff_bcn vbcn vbn dc 0.23

* === VBCP: VBP - 0.255V ===
Bvbcp vbcp vss V = v(vbp) - 0.255

.ends ota_bias_dist

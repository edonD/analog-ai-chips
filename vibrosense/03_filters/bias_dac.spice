* VibroSense Block 03 — 4-Bit Programmable Bias Current DAC
* Binary-weighted current DAC for filter frequency tuning
*
* Ibias_out = Iunit × (8×b3 + 4×b2 + 2×b1 + b0)
* Range: Iunit (code=0001) to 15×Iunit (code=1111)
* Nominal code = 8 (1000b)
*
* Since gm scales linearly with Ibias in subthreshold:
*   gm_effective = gm_nominal × dac_code / 8
*   f0_effective = f0_nominal × dac_code / 8
*
* Implementation: behavioral model using parameterized scaling
* In real silicon: cascode current mirrors with W=2u L=4u,
* binary-weighted by parallel unit cells (1x, 2x, 4x, 8x)
* Switch: NMOS in series with drain, W=1u L=0.15u
*
* Per-channel Iunit values:
*   Ch1: Iunit = 6.25 nA  (Ibias_nom = 50 nA)
*   Ch2: Iunit = 25 nA    (Ibias_nom = 200 nA)
*   Ch3: Iunit = 62.5 nA  (Ibias_nom = 500 nA)
*   Ch4: Iunit = 150 nA   (Ibias_nom = 1.2 uA)
*   Ch5: Iunit = 312.5 nA (Ibias_nom = 2.5 uA)
*
* For behavioral simulation, the DAC effect is modeled by the
* gm_scale parameter in each BPF channel subcircuit:
*   gm_scale = dac_code / 8

* Unit current cell (for documentation / future transistor-level)
* Each Iunit cell: cascode NMOS mirror
* .subckt dac_unit_cell drain gate_n gate_cas vss
* M1 mid gate_n vss vss sky130_fd_pr__nfet_01v8 W=2u L=4u
* M2 drain gate_cas mid vss sky130_fd_pr__nfet_01v8 W=2u L=4u
* .ends dac_unit_cell

* Behavioral DAC subcircuit
* Outputs a current proportional to dac_code
.subckt bias_dac iout vdd vss
+ params: iunit=25n dac_code=8

* Output current = Iunit × dac_code
* Implemented as ideal current source
Idac vdd iout DC {iunit * dac_code}

.ends bias_dac

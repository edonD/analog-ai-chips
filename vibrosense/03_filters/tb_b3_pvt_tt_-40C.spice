* BLOCKER 3: PVT sweep Ch2 — tt @ -40C
.lib "../01_ota/sky130_minimal.lib.spice" tt
.include "../01_ota/ota_foldcasc.spice"
.include "pseudo_res.spice"

.temp -40

Vdd vdd 0 dc 1.8
Vcm vcm 0 dc 0.9

* Fixed calibrated bias voltages (uncorrected)
Vvbn vbn 0 dc 0.5973
Vvbp vbp 0 dc 0.81
Vvbcn vbcn 0 dc 0.8273
Vvbcp vbcp 0 dc 0.555

* Differential AC input
Vinp vinp 0 dc 0.9 ac 0.5
Vinn vinn 0 dc 0.9 ac -0.5

* Positive path
Xota1p vinp int2p int1p vdd 0 vbn vbcn vbp vbcp ota_foldcasc
C1p int1p 0 118.0p
Xpr1p int1p vcm pseudo_res
Xota2p int1p vcm int2p vdd 0 vbn vbcn vbp vbcp ota_foldcasc
C2p int2p 0 260.0p
Xpr2p int2p vcm pseudo_res
Xota3p vcm int1p int1p vdd 0 vbn vbcn vbp vbcp ota_foldcasc

* Negative path
Xota1n vinn int2n int1n vdd 0 vbn vbcn vbp vbcp ota_foldcasc
C1n int1n 0 118.0p
Xpr1n int1n vcm pseudo_res
Xota2n int1n vcm int2n vdd 0 vbn vbcn vbp vbcp ota_foldcasc
C2n int2n 0 260.0p
Xpr2n int2n vcm pseudo_res
Xota3n vcm int1n int1n vdd 0 vbn vbcn vbp vbcp ota_foldcasc

.nodeset v(int1p)=0.9 v(int2p)=0.9
+ v(int1n)=0.9 v(int2n)=0.9

.control
op
ac dec 200 10 100k
wrdata /home/ubuntu/analog-ai-chips/vibrosense/03_filters/b3_pvt_tt_-40C.txt vdb(int1p,int1n) vp(int1p,int1n)
.endc
.end

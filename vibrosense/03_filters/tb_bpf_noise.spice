* TB6: Noise Analysis — All 5 channels
* Measure output noise spectral density and integrated in-band noise
* PASS: Integrated in-band output noise < 1 mVrms per channel
*
* Note: Behavioral OTA (ideal VCCS) has NO intrinsic noise sources.
* Noise comes only from Rbias resistors (Johnson noise).
* Real noise requires transistor-level OTA with thermal + 1/f noise.
*
* For the behavioral model, we add explicit noise sources to model
* expected OTA noise: thermal noise 4kT*gamma/gm per OTA.

.include bpf_ch1.spice
.include bpf_ch2.spice
.include bpf_ch3.spice
.include bpf_ch4.spice
.include bpf_ch5.spice

Vdd vdd 0 1.8
Vss vss 0 0
Vcm vcm 0 0.9
Vin in 0 DC 0.9 AC 0

Xch1 in bp1 vdd vss vcm bpf_ch1
Xch2 in bp2 vdd vss vcm bpf_ch2
Xch3 in bp3 vdd vss vcm bpf_ch3
Xch4 in bp4 vdd vss vcm bpf_ch4
Xch5 in bp5 vdd vss vcm bpf_ch5

.control
noise v(bp1) Vin dec 100 1 100k
print inoise_total onoise_total
wrdata noise_ch1.txt onoise_spectrum

noise v(bp2) Vin dec 100 1 100k
wrdata noise_ch2.txt onoise_spectrum

noise v(bp3) Vin dec 100 1 100k
wrdata noise_ch3.txt onoise_spectrum

noise v(bp4) Vin dec 100 1 100k
wrdata noise_ch4.txt onoise_spectrum

noise v(bp5) Vin dec 100 1 100k
wrdata noise_ch5.txt onoise_spectrum
.endc

.end

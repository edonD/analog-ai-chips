* Extract bias voltages from Block 00 generator at each corner
.lib "/home/ubuntu/pdk/sky130A/libs.tech/ngspice/sky130.lib.spice" tt
.include "../00_bias/bias_distribution/design_full.cir"
.option scale=1e-6

Vdd vdd 0 dc 1.8
Xbias vdd 0 iref_out vbn vbcn vbp vbcp bias_generator_full

.control
op
echo "CORNER=tt TEMP=27"
print v(vbn) v(vbcn) v(vbp) v(vbcp) @vdd[i]
.endc
.end

* Pseudo-resistor: back-to-back diode-connected PMOS
* Provides >100GΩ resistance in subthreshold for DC bias
* Standard technique for Gm-C filter DC biasing
*
* Two PMOS in anti-parallel: one conducts for V(a)>V(b), the other for V(b)>V(a)
* Net effect: bidirectional very-high-resistance element
*
* Ports: a, b (symmetric)

.subckt pseudo_res a b
* PMOS1: gate=drain=a, source=b, bulk=b (body tied to source)
XMp1 a a b b sky130_fd_pr__pfet_01v8 W=0.42u L=10u nf=1
* PMOS2: gate=drain=b, source=a, bulk=a (body tied to source)
XMp2 b b a a sky130_fd_pr__pfet_01v8 W=0.42u L=10u nf=1
.ends pseudo_res

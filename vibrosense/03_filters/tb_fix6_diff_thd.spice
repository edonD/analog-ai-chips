* Fix #6: Pseudo-differential Tow-Thomas for HD2 cancellation
* Two single-ended filters with inverted inputs. Differential output.
* Ch2: C1=63p C2=120p, LE bias (Vbn=0.565 Vbp=0.860)

.lib "../01_ota/sky130_minimal.lib.spice" tt
.include "../01_ota/ota_foldcasc.spice"

Vdd vdd 0 dc 1.8
Vbn  vbn  0 dc 0.565
Vbcn vbcn 0 dc 0.795
Vbp  vbp  0 dc 0.860
Vbcp vbcp 0 dc 0.605
Vcm  vcm  0 dc 0.9

* Differential input: Vin+ = Vcm + Vsig, Vin- = Vcm - Vsig
* 200mVpp = 100mV amplitude per side (50mV each in pseudo-diff)
Vinp inp 0 dc 0.9 SIN(0.9 0.05 1035 0 0)
Vinn inn 0 dc 0.9 SIN(0.9 -0.05 1035 0 0)

* === Positive path ===
Xota1p inp int2p int1p vdd 0 vbn vbcn vbp vbcp ota_foldcasc
C1p int1p 0 63p
Rb1p int1p vcm 1G
Xota2p int1p vcm int2p vdd 0 vbn vbcn vbp vbcp ota_foldcasc
C2p int2p 0 120p
Rb2p int2p vcm 1G
Xota3p vcm int1p int1p vdd 0 vbn vbcn vbp vbcp ota_foldcasc

* === Negative path (same topology, inverted input) ===
Xota1n inn int2n int1n vdd 0 vbn vbcn vbp vbcp ota_foldcasc
C1n int1n 0 63p
Rb1n int1n vcm 1G
Xota2n int1n vcm int2n vdd 0 vbn vbcn vbp vbcp ota_foldcasc
C2n int2n 0 120p
Rb2n int2n vcm 1G
Xota3n vcm int1n int1n vdd 0 vbn vbcn vbp vbcp ota_foldcasc

.nodeset v(int1p)=0.9 v(int2p)=0.9 v(int1n)=0.9 v(int2n)=0.9

.control
* Transient: 30ms, skip 10ms
tran 0.5u 30m 10m

* Write single-ended outputs and differential output
wrdata fix6_diff_thd.txt v(int1p) v(int1n)
.endc
.end

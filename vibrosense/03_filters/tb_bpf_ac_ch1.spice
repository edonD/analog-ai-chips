* TB1: AC Sweep — Channel 1 (100-500 Hz, f0=224 Hz, Q=0.75)
.include bpf_ch1.spice

Vdd vdd 0 1.8
Vss vss 0 0
Vcm vcm 0 0.9
Vin in 0 DC 0.9 AC 1

Xbpf in bp_out vdd vss vcm bpf_ch1

.control
ac dec 500 1 100k
wrdata ac_ch1.txt v(bp_out)
.endc
.end

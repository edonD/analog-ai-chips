* Testbench: 4-bit binary-weighted cascode current mirror DAC
* Single-point test at code 8 (nominal). Full sweep: run_dac_sweep.py
* Iunit = 25nA (Ch2 nominal: code 8 -> 200nA)

.lib "../01_ota/sky130_minimal.lib.spice" tt
.include "bias_dac_real.spice"

Vdd vdd 0 dc 1.8

* Reference current: Iunit = 25nA
Iref vdd iref_node 25n

* Output measurement: force Vout=0.9V and measure current sunk
Vout iout_node 0 dc 0.9

* DAC instance — code 8 = b3=1.8V, b2=b1=b0=0V
Xdac iref_node iout_node vdd 0 b0 b1 b2 b3 bias_dac_real

Vb0 b0 0 dc 0
Vb1 b1 0 dc 0
Vb2 b2 0 dc 0
Vb3 b3 0 dc 1.8

.control
op
echo "=== Bias DAC Real — Code 8 Test ==="
print v(iref_node) v(iout_node)
print v(xdac.gate_n) v(xdac.gate_c)
let iout = -i(vout)
let iout_na = iout * 1e9
echo "Iout = $&iout_na nA (expected: 200nA)"
let err = 100 * (iout_na - 200) / 200
echo "Error = $&err %"
echo ""
echo "For full code sweep with DNL/INL analysis, run:"
echo "  python3 run_dac_sweep.py"
.endc
.end

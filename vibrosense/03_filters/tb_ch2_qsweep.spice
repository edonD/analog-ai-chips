* Sweep OTA3 bias (Vbn3) to find Q control range
* At Vbn3 = Vbn (0.65V): gm3=gm → Q=1
* At Vbn3 < Vbn: gm3 < gm → Q > 1
* At Vbn3 > Vbn: gm3 > gm → Q < 1

.lib "../01_ota/sky130_minimal.lib.spice" tt
.include "../01_ota/ota_foldcasc.spice"
.include "bpf_ch2_real.spice"

Vdd vdd 0 dc 1.8
Vss vss 0 dc 0
Vbn  vbn  0 dc 0.65
Vbcn vbcn 0 dc 0.88
Vbp  vbp  0 dc 0.73
Vbcp vbcp 0 dc 0.475
Vcm vcm 0 dc 0.9

Vin in 0 dc 0.9 ac 1

* Filter with separate Vbn3 for OTA3
.param vbn3_val = 0.65
Vbn3 vbn3 0 dc {vbn3_val}

Xbpf in bp_out vdd vss vcm vbn vbcn vbp vbcp vbn3 bpf_ch2_real

.control
* Q > 1: lower Vbn3 (less gm3 → more Q)
alter vbn3 0.64
op
ac dec 200 1 100k
wrdata ch2_q_vbn3_0.64.txt vdb(bp_out)

alter vbn3 0.63
op
ac dec 200 1 100k
wrdata ch2_q_vbn3_0.63.txt vdb(bp_out)

alter vbn3 0.62
op
ac dec 200 1 100k
wrdata ch2_q_vbn3_0.62.txt vdb(bp_out)

alter vbn3 0.60
op
ac dec 200 1 100k
wrdata ch2_q_vbn3_0.60.txt vdb(bp_out)

* Q < 1: higher Vbn3 (more gm3 → less Q)
alter vbn3 0.66
op
ac dec 200 1 100k
wrdata ch2_q_vbn3_0.66.txt vdb(bp_out)

alter vbn3 0.67
op
ac dec 200 1 100k
wrdata ch2_q_vbn3_0.67.txt vdb(bp_out)

alter vbn3 0.68
op
ac dec 200 1 100k
wrdata ch2_q_vbn3_0.68.txt vdb(bp_out)

.endc
.end

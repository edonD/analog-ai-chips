* THD Measurement — Ch4 with REAL transistor-level OTA
* Input: 200mVpp (100mV amplitude) sine at f0=6851Hz

.lib "../01_ota/sky130_minimal.lib.spice" tt
.include "../01_ota/ota_foldcasc.spice"
.include "bpf_ch4_real.spice"

Vdd vdd 0 dc 1.8
Vbn  vbn  0 dc 0.565
Vbcn vbcn 0 dc 0.795
Vbp  vbp  0 dc 0.860
Vbcp vbcp 0 dc 0.605
Vcm vcm 0 dc 0.9

Vin in 0 dc 0.9 SIN(0.9 0.1 6851 0 0)

Xbpf in bp_out vdd vss vcm vbn vbcn vbp vbcp bpf_ch4_real
Vss vss 0 dc 0

.nodeset v(xbpf.int1)=0.9 v(xbpf.int2)=0.9

.control
tran 0.5u 30m 10m
wrdata thd_real_ch4.txt v(bp_out)
.endc
.end

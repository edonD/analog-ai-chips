* VERIFICATION: Ch3 pseudo-diff BPF
.lib "../01_ota/sky130_minimal.lib.spice" tt
.include "../01_ota/ota_foldcasc.spice"
.include "pseudo_res.spice"
.include "bpf_ch3_real.spice"
Vdd vdd 0 dc 1.8
Vcm vcm 0 dc 0.9
Vss vss 0 dc 0
Vbn vbn 0 dc 0.5973
Vbcn vbcn 0 dc 0.8273
Vbp vbp 0 dc 0.81
Vbcp vbcp 0 dc 0.555
Vinp inp 0 dc 0.9 ac 0.5
Vinn inn 0 dc 0.9 ac -0.5
Xbpf inp inn bp_outp bp_outn vdd vss vcm vbn vbcn vbp vbcp bpf_ch3_real
.nodeset v(xbpf.int1p)=0.9 v(xbpf.int2p)=0.9
+ v(xbpf.int1n)=0.9 v(xbpf.int2n)=0.9
.control
op
ac dec 200 10 200k
wrdata verify_ch3_ac.txt vdb(bp_outp,bp_outn)
.endc
.end

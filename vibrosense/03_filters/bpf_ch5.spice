* VibroSense Block 03 — Channel 5 Band-Pass Filter
* Tow-Thomas Biquad: f0=14142 Hz, Q=1.41, BW=10000 Hz (10-20 kHz)
* Detects: Incipient faults (broadband ultrasonic)
*
* Design parameters:
*   gm1 = gm2 = 2*pi*14142*10p = 888.6 nS
*   gm3 = gm/Q = 888.6n/1.41 = 630.2 nS
*   C1 = C2 = 10 pF
*   Peak gain G0 = Q = 1.41 → +2.99 dB

.include ota_behavioral.spice

.subckt bpf_ch5 vin bp_out vdd vss vcm
+ params: gm_scale=1.0

.param gm_nom = 888.6n
.param gm1_val = {gm_nom * gm_scale}
.param gm2_val = {gm_nom * gm_scale}
.param gm3_val = {630.2n * gm_scale}

Xota1 vin int2 int1 vdd vss ota_gmc gm_val={gm1_val}
C1 int1 vss 10p
Rbias1 int1 vcm 10G

Xota2 int1 vcm int2 vdd vss ota_gmc gm_val={gm2_val}
C2 int2 vss 10p
Rbias2 int2 vcm 10G

Xota3 vcm int1 int1 vdd vss ota_gmc gm_val={gm3_val}

Rout_tap bp_out int1 1m

.ends bpf_ch5

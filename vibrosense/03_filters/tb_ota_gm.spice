* Measure OTA gm vs bias current
* Sweep Vbn to vary tail current and measure gm at each point

.lib "../01_ota/sky130_minimal.lib.spice" tt
.include "../01_ota/ota_foldcasc.spice"

Vdd vdd 0 dc 1.8
Vbn  vbn  0 dc 0.65
Vbcn vbcn 0 dc 0.88
Vbp  vbp  0 dc 0.73
Vbcp vbcp 0 dc 0.475

Vinp vinp 0 dc 0.9 ac 1
Lbreak vout vinn 1G
Cdc vinn 0 1

Xota vinp vinn vout vdd 0 vbn vbcn vbp vbcp ota_foldcasc
CL vout 0 10p

.control
* Measure at default bias
ac dec 50 0.1 1Meg
meas ac ugb0 WHEN vdb(vout)=0 FALL=1
let gm0 = ugb0 * 2 * 3.14159 * 10e-12
echo "Default bias (Vbn=0.65V):"
print ugb0 gm0
echo "Supply current:"
print @vdd[i]

* Now try different Vbn values to map gm vs Ibias
* Lower Vbn = lower Itail = lower gm
foreach vbn_val 0.50 0.52 0.54 0.56 0.58 0.60 0.62 0.65
  alter vbn $vbn_val
  op
  let isupply = -@vdd[i]
  ac dec 50 0.1 1Meg
  meas ac ugb_test WHEN vdb(vout)=0 FALL=1
  let gm_test = ugb_test * 2 * 3.14159 * 10e-12
  echo "Vbn=$vbn_val Isupply=$&isupply UGB=$&ugb_test gm=$&gm_test"
end

.endc
.end

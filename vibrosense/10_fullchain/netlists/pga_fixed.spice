* UNIT-FIXED copy of pga.spice (bare microns -> explicit u suffix)
* VibroSense Block 02: Capacitive-Feedback Programmable Gain Amplifier
* SKY130A Process
*
* Gain = Cin/Cf, switched by NMOS pass gates
* 4 gain settings: 1x (00), 4x (01), 16x (10), 64x (11)
*
* Topology: vin --[Cin_k]-- mid_k --[NMOS switch]-- inn --[Cf]-- vout
*   Switch between Cin and virtual ground (inn) for best linearity:
*   both switch terminals stay near 0.9V, Vgs constant.
*
* Pinout: vin vout vcm vdd vss g1 g0
* Requires: ota_behavioral (or ota_pga_v2) subcircuit defined before this file
* Requires: sky130_fd_pr__nfet_01v8 model loaded
* Use with: .option scale=1e-6

.subckt pga vin vout vcm vdd vss g1 g0

** ================================================================
** 2-to-4 DECODER (behavioral, one-hot output)
** sel0=1x, sel1=4x, sel2=16x, sel3=64x
** ================================================================
Bsel0 sel0 vss V = {(V(g1,vss) < 0.9 && V(g0,vss) < 0.9) ? 1.8 : 0}
Bsel1 sel1 vss V = {(V(g1,vss) < 0.9 && V(g0,vss) > 0.9) ? 1.8 : 0}
Bsel2 sel2 vss V = {(V(g1,vss) > 0.9 && V(g0,vss) < 0.9) ? 1.8 : 0}
Bsel3 sel3 vss V = {(V(g1,vss) > 0.9 && V(g0,vss) > 0.9) ? 1.8 : 0}

** ================================================================
** SWITCHED INPUT CAPACITOR NETWORK
** vin --[Cin_k]-- mid_k --[NMOS switch D=mid G=sel S=inn B=vss]-- inn
** Switch on virtual-ground side for constant Vgs and minimal Vds
** ================================================================

* Gain = 1x: Cin = 1 pF, switch W=0.42u/L=0.15u
Cin1 vin mid1 1p
XS1 mid1 sel0 inn vss sky130_fd_pr__nfet_01v8 w=0.42u l=0.15u

* Gain = 4x: Cin = 4 pF, switch W=0.42u/L=0.15u
Cin2 vin mid2 4p
XS2 mid2 sel1 inn vss sky130_fd_pr__nfet_01v8 w=0.42u l=0.15u

* Gain = 16x: Cin = 16 pF, switch W=1u/L=0.15u
Cin3 vin mid3 16p
XS3 mid3 sel2 inn vss sky130_fd_pr__nfet_01v8 w=1u l=0.15u

* Gain = 64x: Cin = 64 pF, switch W=5u/L=0.15u
Cin4 vin mid4 64p
XS4 mid4 sel3 inn vss sky130_fd_pr__nfet_01v8 w=5u l=0.15u

** ================================================================
** MID-NODE DISCHARGE RESISTORS
** Prevent charge buildup on floating mid nodes when switches are OFF
** 10 GOhm to vcm: negligible signal loading, provides DC path
** In real design: handled by reset switches or bottom-plate sampling
** ================================================================
Rmid1 mid1 vcm 10G
Rmid2 mid2 vcm 10G
Rmid3 mid3 vcm 10G
Rmid4 mid4 vcm 10G

** ================================================================
** FEEDBACK CAPACITOR
** Cf = 1 pF (fixed, sets gain denominator)
** ================================================================
Cf inn vout 1p

** ================================================================
** DC BIAS RESISTOR (in parallel with Cf)
** Sets DC operating point via OTA feedback loop
** High-pass corner: 1/(2*pi*10G*1p) = 16 Hz
** Real design uses back-to-back subthreshold PMOS pseudo-resistor
** ================================================================
Rpseudo inn vout 10G

** ================================================================
** OTA (behavioral model — replace with ota_pga_v2 for real design)
** Non-inverting (+) = vcm, Inverting (-) = inn
** ================================================================
Xota vcm inn vout vdd vss ota_behavioral

.ends pga

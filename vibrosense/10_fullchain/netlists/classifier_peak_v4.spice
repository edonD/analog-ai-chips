* VibroSense-1 Classifier — Behavioral SPICE Model
* RETRAINED v5: weights from pseudo-inverse on actual sim peak features
* Features: 5 per-channel peaks + rms_out + peak_out + rms_ref
*
* Actual measured feature ranges (median, last 50ms):
*   in0 (venv1): 0.955-0.967 V
*   in1 (venv2): 0.997-1.004 V
*   in2 (venv3): 0.996-1.009 V
*   in3 (venv4): 0.935-1.033 V
*   in4 (venv5): 0.918-1.045 V
*   in5 (rms_out): 1.501-1.552 V
*   in6 (peak_out): 1.185-1.225 V
*   in7 (rms_ref): 1.616 V (constant)
*
* Trained via pseudo-inverse on actual sim data — 4/4 on training points
*
* Architecture:
*   - 4 VCVS compute weighted sums (one per class)
*   - WTA comparator selects maximum
*   - Output encoded as: class 0=0V, 1=0.45V, 2=0.9V, 3=1.35V

.subckt classifier_behavioral
+ in0 in1 in2 in3 in4 in5 in6 in7
+ class_out class_valid_out
+ vdd vss

* ================================================
* Weighted sum computation for each class
* Score = sum(w[k][i] * V(in_i)/1.8) + bias[k]
* ================================================

* Class 0 (normal)
* bias = 69.51
Bscore0 score0 vss V = {
+    -28.964 * V(in0,vss)/1.8
+  + 65.064 * V(in1,vss)/1.8
+  + 24.723 * V(in2,vss)/1.8
+  + -215.353 * V(in3,vss)/1.8
+  + 19.524 * V(in4,vss)/1.8
+  + -30.267 * V(in5,vss)/1.8
+  + -33.358 * V(in6,vss)/1.8
+  + 62.406 * V(in7,vss)/1.8
+  + 69.505 }

* Class 1 (inner_race)
* bias = 155.76
Bscore1 score1 vss V = {
+    -131.023 * V(in0,vss)/1.8
+  + 182.103 * V(in1,vss)/1.8
+  + 13.483 * V(in2,vss)/1.8
+  + -477.113 * V(in3,vss)/1.8
+  + 418.331 * V(in4,vss)/1.8
+  + -271.849 * V(in5,vss)/1.8
+  + -77.844 * V(in6,vss)/1.8
+  + 139.852 * V(in7,vss)/1.8
+  + 155.760 }

* Class 2 (ball)
* bias = -121.70
Bscore2 score2 vss V = {
+    -12.807 * V(in0,vss)/1.8
+  + -201.709 * V(in1,vss)/1.8
+  + -209.445 * V(in2,vss)/1.8
+  + 292.010 * V(in3,vss)/1.8
+  + 8.073 * V(in4,vss)/1.8
+  + 459.885 * V(in5,vss)/1.8
+  + -147.563 * V(in6,vss)/1.8
+  + -109.266 * V(in7,vss)/1.8
+  + -121.695 }

* Class 3 (outer_race)
* bias = -100.57
Bscore3 score3 vss V = {
+    173.757 * V(in0,vss)/1.8
+  + -43.485 * V(in1,vss)/1.8
+  + 172.888 * V(in2,vss)/1.8
+  + 399.318 * V(in3,vss)/1.8
+  + -444.905 * V(in4,vss)/1.8
+  + -156.239 * V(in5,vss)/1.8
+  + 259.999 * V(in6,vss)/1.8
+  + -90.301 * V(in7,vss)/1.8
+  + -100.572 }

* ================================================
* Winner-Take-All (argmax)
* Output voltage encodes class: 0=0V, 1=0.45V, 2=0.9V, 3=1.35V
* ================================================

Bclass class_out vss V = {
+  ( V(score0,vss) >= V(score1,vss)
+    && V(score0,vss) >= V(score2,vss)
+    && V(score0,vss) >= V(score3,vss) ) ? 0.0
+  : ( V(score1,vss) >= V(score0,vss)
+    && V(score1,vss) >= V(score2,vss)
+    && V(score1,vss) >= V(score3,vss) ) ? 0.45
+  : ( V(score2,vss) >= V(score0,vss)
+    && V(score2,vss) >= V(score1,vss)
+    && V(score2,vss) >= V(score3,vss) ) ? 0.9
+  : 1.35 }

* Class valid passthrough
Bcv class_valid_out vss V = { 0 }

.ends classifier_behavioral

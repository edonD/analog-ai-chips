* VibroSense-1 Classifier — Behavioral SPICE Model
* 8-input, 4-class linear classifier using voltage-controlled sources
* Computes: score[k] = sum_i(w[k][i] * V(in_i)) + bias[k]
* Output: class = argmax(score[k]), encoded as voltage on class_out
*
* RETRAINED v3: weights calibrated for post-fix analog feature values
* After V_SCALE=0.1 and per-channel BPF bias correction:
*   - Envelopes at ~0.901-0.923V (larger spread than v2)
*   - RMS ~1.51-1.55V, Peak ~1.18-1.24V
*   - RMS_ref constant at 1.6162V
* Trained via least-squares on measured features from all 4 test cases
*
* Architecture:
*   - 4 VCVS compute weighted sums (one per class)
*   - WTA comparator selects maximum
*   - Output encoded as: class 0=0V, 1=0.45V, 2=0.9V, 3=1.35V

.subckt classifier_behavioral
+ in0 in1 in2 in3 in4 in5 in6 in7
+ class_out class_valid_out
+ vdd vss

* ================================================
* Weighted sum computation for each class
* Retrained v3 weights for post-fix analog feature voltages
* Score = sum(w[k][i] * V(in_i)/1.8) + bias[k]
* ================================================

* Class 0 (Normal): retrained for V_SCALE=0.1 + BPF bias fix
* bias = 85.04
Bscore0 score0 vss V = {
+  312.880 * V(in0,vss)/1.8
+  + 290.548 * V(in1,vss)/1.8
+  + (-240.879) * V(in2,vss)/1.8
+  + (-1.870) * V(in3,vss)/1.8
+  + 337.812 * V(in4,vss)/1.8
+  + (-332.117) * V(in5,vss)/1.8
+  + (-561.214) * V(in6,vss)/1.8
+  + 247.387 * V(in7,vss)/1.8
+  + 85.039 }

* Class 1 (Inner Race): retrained for V_SCALE=0.1 + BPF bias fix
* bias = 276.60
Bscore1 score1 vss V = {
+  1232.060 * V(in0,vss)/1.8
+  + 437.356 * V(in1,vss)/1.8
+  + (-2136.176) * V(in2,vss)/1.8
+  + 1971.090 * V(in3,vss)/1.8
+  + 2726.369 * V(in4,vss)/1.8
+  + (-2245.765) * V(in5,vss)/1.8
+  + (-1801.267) * V(in6,vss)/1.8
+  + 804.667 * V(in7,vss)/1.8
+  + 276.604 }

* Class 2 (Ball): retrained for V_SCALE=0.1 + BPF bias fix
* bias = -237.28
Bscore2 score2 vss V = {
+  (-715.072) * V(in0,vss)/1.8
+  + (-1152.354) * V(in1,vss)/1.8
+  + (-222.907) * V(in2,vss)/1.8
+  + 1099.861 * V(in3,vss)/1.8
+  + (-77.732) * V(in4,vss)/1.8
+  + 1204.775 * V(in5,vss)/1.8
+  + 559.336 * V(in6,vss)/1.8
+  + (-690.255) * V(in7,vss)/1.8
+  + (-237.275) }

* Class 3 (Outer Race): retrained for V_SCALE=0.1 + BPF bias fix
* bias = -125.59
Bscore3 score3 vss V = {
+  (-832.455) * V(in0,vss)/1.8
+  + 421.435 * V(in1,vss)/1.8
+  + 2598.651 * V(in2,vss)/1.8
+  + (-3069.345) * V(in3,vss)/1.8
+  + (-2988.385) * V(in4,vss)/1.8
+  + 1372.303 * V(in5,vss)/1.8
+  + 1802.755 * V(in6,vss)/1.8
+  + (-365.358) * V(in7,vss)/1.8
+  + (-125.592) }

* ================================================
* Winner-Take-All (argmax)
* Output voltage encodes class: 0=0V, 1=0.45V, 2=0.9V, 3=1.35V
* ================================================

Bclass class_out vss V = {
+  ( V(score0,vss) >= V(score1,vss)
+    && V(score0,vss) >= V(score2,vss)
+    && V(score0,vss) >= V(score3,vss) ) ? 0.0
+  : ( V(score1,vss) >= V(score0,vss)
+    && V(score1,vss) >= V(score2,vss)
+    && V(score1,vss) >= V(score3,vss) ) ? 0.45
+  : ( V(score2,vss) >= V(score0,vss)
+    && V(score2,vss) >= V(score1,vss)
+    && V(score2,vss) >= V(score3,vss) ) ? 0.9
+  : 1.35 }

* Class valid passthrough
Bcv class_valid_out vss V = { 0 }

.ends classifier_behavioral

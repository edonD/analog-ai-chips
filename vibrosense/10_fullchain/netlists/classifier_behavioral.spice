* VibroSense-1 Classifier — Behavioral SPICE Model
* 8-input, 4-class linear classifier using voltage-controlled sources
* Computes: score[k] = sum_i(w[k][i] * V(in_i)) + bias[k]
* Output: class = argmax(score[k]), encoded as voltage on class_out
*
* RETRAINED for actual analog voltage ranges (v2)
* Previous weights assumed features spanning [0, 1.8V]
* Actual analog features: envelopes at ~0.900-0.910V, RMS ~1.57V, peak ~1.0-1.13V
* New weights trained on measured feature values from 4 test case simulations
* using least-squares fit with target scores of +5 (correct) / -5 (wrong)
*
* Architecture:
*   - 4 VCVS compute weighted sums (one per class)
*   - WTA comparator selects maximum
*   - Output encoded as: class 0=0V, 1=0.45V, 2=0.9V, 3=1.35V

.subckt classifier_behavioral
+ in0 in1 in2 in3 in4 in5 in6 in7
+ class_out class_valid_out
+ vdd vss

* ================================================
* Weighted sum computation for each class
* Retrained weights for actual analog feature voltages
* Score = sum(w[k][i] * V(in_i)/1.8) + bias[k]
* ================================================

* Class 0 (Normal): weights = [805.38, -249.29, -2403.51, -1760.90, -200.32, 541.88, 99.58, 1116.77]
* bias = 383.88
Bscore0 score0 vss V = {
+  805.384 * V(in0,vss)/1.8
+  + (-249.290) * V(in1,vss)/1.8
+  + (-2403.513) * V(in2,vss)/1.8
+  + (-1760.901) * V(in3,vss)/1.8
+  + (-200.322) * V(in4,vss)/1.8
+  + 541.883 * V(in5,vss)/1.8
+  + 99.578 * V(in6,vss)/1.8
+  + 1116.769 * V(in7,vss)/1.8
+  + 383.880 }

* Class 1 (Inner Race): weights = [1130.39, -1133.33, -4389.49, -513.91, 1956.98, 540.52, 366.31, 645.02]
* bias = 221.72
Bscore1 score1 vss V = {
+  1130.392 * V(in0,vss)/1.8
+  + (-1133.330) * V(in1,vss)/1.8
+  + (-4389.487) * V(in2,vss)/1.8
+  + (-513.912) * V(in3,vss)/1.8
+  + 1956.977 * V(in4,vss)/1.8
+  + 540.517 * V(in5,vss)/1.8
+  + 366.306 * V(in6,vss)/1.8
+  + 645.020 * V(in7,vss)/1.8
+  + 221.720 }

* Class 2 (Ball): weights = [-278.38, -1260.39, -761.74, 4388.66, 4223.19, -490.50, -356.80, -2041.00]
* bias = -701.58
Bscore2 score2 vss V = {
+  (-278.378) * V(in0,vss)/1.8
+  + (-1260.388) * V(in1,vss)/1.8
+  + (-761.737) * V(in2,vss)/1.8
+  + 4388.663 * V(in3,vss)/1.8
+  + 4223.186 * V(in4,vss)/1.8
+  + (-490.499) * V(in5,vss)/1.8
+  + (-356.801) * V(in6,vss)/1.8
+  + (-2041.003) * V(in7,vss)/1.8
+  + (-701.578) }

* Class 3 (Outer Race): weights = [-1659.73, 2641.18, 7554.77, -2112.59, -5979.83, -595.34, -109.19, 274.78]
* bias = 94.45
Bscore3 score3 vss V = {
+  (-1659.728) * V(in0,vss)/1.8
+  + 2641.181 * V(in1,vss)/1.8
+  + 7554.767 * V(in2,vss)/1.8
+  + (-2112.588) * V(in3,vss)/1.8
+  + (-5979.835) * V(in4,vss)/1.8
+  + (-595.338) * V(in5,vss)/1.8
+  + (-109.190) * V(in6,vss)/1.8
+  + 274.780 * V(in7,vss)/1.8
+  + 94.453 }

* ================================================
* Winner-Take-All (argmax)
* Output voltage encodes class: 0=0V, 1=0.45V, 2=0.9V, 3=1.35V
* ================================================

Bclass class_out vss V = {
+  ( V(score0,vss) >= V(score1,vss)
+    && V(score0,vss) >= V(score2,vss)
+    && V(score0,vss) >= V(score3,vss) ) ? 0.0
+  : ( V(score1,vss) >= V(score0,vss)
+    && V(score1,vss) >= V(score2,vss)
+    && V(score1,vss) >= V(score3,vss) ) ? 0.45
+  : ( V(score2,vss) >= V(score0,vss)
+    && V(score2,vss) >= V(score1,vss)
+    && V(score2,vss) >= V(score3,vss) ) ? 0.9
+  : 1.35 }

* Class valid passthrough
Bcv class_valid_out vss V = { 0 }

.ends classifier_behavioral
